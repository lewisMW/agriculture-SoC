ADE simulation setup
Test SoC_sample_Hold_1_1: SoC/sample_Hold_1/config, simulator ams
  Variables: wireopt = 0
  Temperature: 27
  Analysis tran: stop=0.01 errpreset=conservative
  Signals: /net1, /net2, /I0/holdSig (terminal)
Test SoC_sample_Hold_1_3: SoC/sample_Hold_1/schematic, simulator spectre
  Variables: wireopt = nil
  Temperature: 27
  Analysis tran: stop=10n errpreset=conservative
Test SoC_sample_Hold_1_2: SoC/sample_Hold_1/config, simulator ams
  Variables: wireopt = 0
  Temperature: 27
  Analysis tran: stop=100n errpreset=conservative
  Signals: /input, /trigger, /Current
