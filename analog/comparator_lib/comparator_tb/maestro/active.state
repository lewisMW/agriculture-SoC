ADE simulation setup
Test comparator_lib_comparator_tb_1: comparator_lib/comparator_tb/schematic, simulator spectre
  Models: /home/jaime/sky130_release_0.1.0/libs/sky130_fd_pr_main/../../models/sky130.lib.spice[tt]
  Variables: Vin = 1
  Temperature: 27
  Analysis tran: stop=1
  Signals: /Vout as Vout, /Vin as Vin
Run mode: Single Run, Sweeps and Corners
