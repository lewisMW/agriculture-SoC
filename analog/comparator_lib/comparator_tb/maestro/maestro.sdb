ADE simulation setup
Run mode: Single Run, Sweeps and Corners
Tests:
  comparator_lib_comparator_tb_1: comparator_lib/comparator_tb/schematic, simulator spectre
    Variables: Vin = 1
    Outputs: Vout; Vin
