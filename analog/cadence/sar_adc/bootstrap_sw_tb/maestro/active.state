ADE simulation setup
Test bootstrap_switch_lib_bootstrap_sw_tb_1: sar_adc/bootstrap_sw_tb/config, simulator spectre
  Models: /home/jaime/sky130_release_0.1.0/libs/sky130_fd_pr_main/../../models/sky130.lib.spice[tt]
  Variables: vin = 1; Vcm = 900m; fin = 30k; Rpad = 0; Tclk = 10u; vdda = 1.8; vssa = 0; amp = 1.7; Va = amp/2
  Temperature: 27
  Analysis tran: stop=100u
  Output diff = ((VT("/en") / 1.8) * (VT("/vout") - VT("/vin")))
  Signals: /vin as vin, /vout as vout, /en as en, /bs_switch/vbsh as vbsh, /bs_switch/vbsl as vbsl, /bs_switch/net2 as net2, /bs_switch/enb as enb
Run mode: Single Run, Sweeps and Corners
