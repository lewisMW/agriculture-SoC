ADE simulation setup
Run mode: Single Run, Sweeps and Corners
Tests:
  bootstrap_switch_lib_bootstrap_sw_tb_1: sar_adc/bootstrap_sw_tb/config, simulator spectre
    Variables: amp = 1.7; vin = 1; Vcm = 900m; fin = 30k; Rpad = 0; Tclk = 10u; vdda = 1.8; vssa = 0; Va = amp/2
    Outputs: vin; vout; en; /C0/PLUS; vbsh; vbsl; net2; enb; "/"; diff
