//Verilog-AMS HDL for "adc_analog_lib", "switch" "verilogams"

`include "constants.vams"
`include "disciplines.vams"

module switch_adc ( p, n, ctrl );
	input ctrl;
	inout p, n;
	electrical p, n;
	electrical ctrl;

	parameter real ron   = 10e-3;       // on-resistance  (?)
	parameter real roff  = 1e12;         // off-resistance (?)
	parameter real trise = 1e-9;        // switch-on  time (s)
	parameter real tfall = 1e-9;        // switch-off time (s)
	parameter real vth	= 0.6;

	real r1;

analog begin
	if (V(ctrl) > vth)
		r1 = ron;
	else
		r1 = roff;

	I(p,n) <+ V(p,n)/transition(r1, 0, trise, tfall);
end

endmodule
