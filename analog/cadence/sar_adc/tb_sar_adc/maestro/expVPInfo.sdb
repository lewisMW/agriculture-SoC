ADE simulation setup
Global variables:
  vdd = 1.8
  vss = 0
