ADE simulation setup
Run mode: Single Run, Sweeps and Corners
Tests:
  sar_adc_tb_sar_adc_1: sar_adc/tb_sar_adc/config, simulator ams
    Variables: vdd = 1.8; vss = 0
    Outputs: /vp; /vn; /result<7:0>; /valid; /clk; /en; /rstn; /cal
Global variables:
  vdd = 1.8
  vss = 0
