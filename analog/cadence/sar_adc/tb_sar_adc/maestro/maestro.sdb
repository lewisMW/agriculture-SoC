ADE simulation setup
Run mode: Single Run, Sweeps and Corners
Tests:
  sar_adc_tb_sar_adc_1: sar_adc/tb_sar_adc/config, simulator ams
    Variables: vdd_supply = 1.8; vss_supply = 0; fclk = 1000000
    Outputs: /vp; /vn; /result<7:0>; /valid; /clk; /en; /rstn; /cal; /I0/cdac_pout; /I0/cdac_nout
  sar_adc_sine_fft: sar_adc/tb_sar_adc/config, simulator spectre
    Variables: fs = fclk/10; fclk = 1000000; Nfft = 1024; M_cycles = 31, 509; fin_1 = fs*M_cycles/Nfft; N_drop = 2; t_drop = N_drop/fs; t_start = 100.5u; t0 = t_start + t_drop; t1 = t0 + M_cycles/fin_1; vssa = 0; vdda = 1.8; v_ref = vdda; v_cm = 0.9; t_sim = t_start + t_drop + (t1-t0) + 1/fs; fin_2 = 0
    Outputs: /vp; /vn; /result<7:0>; /valid; /clk; /en; /rstn; /cal; /I0/cdac_pout; /I0/cdac_nout; codes; (codes * 2); (dft codes); fft_codes; t0; vin; fft_vin; sinad_codes; enob; spectrumMeasurement(codes t VAR("t0") VAR("t1") VAR("Nfft") 0 50000 0 "Rectangular" 0 0 1 "enob"); thd; spectrumMeasurement(codes t VAR("t0") VAR("t1") VAR("Nfft") 0 50000 0 "Rectangular" 0 0 1 "thd"); spectrumMeasurement(codes t VAR("t0") VAR("t1") VAR("Nfft") 0 50000 0 "Rectangular" 0 0 1 "snhr"); spectrumMeasurement(codes t VAR("t0") VAR("t1") VAR("Nfft") 0 50000 0 "Rectangular" 0 0 1 "afdr"); sfdr; snr; /vout; sinad_vout; fft_vout; sigpower
  sar_adc_sine_linearity: sar_adc/tb_sar_adc/schematic, simulator spectre
  sar_adc_sine_two_tone: sar_adc/tb_sar_adc/config, simulator spectre
    Variables: fs = fclk/10; fclk = 1000000; Nfft = 1024; M_cycles_1 = 59; M_cycles_2 = 67; fin_1 = fs*M_cycles_1/Nfft; fin_2 = fs*M_cycles_2/Nfft; N_drop = 2; t_drop = N_drop/fs; t_start = 100.5u; t0 = t_start + t_drop; t1 = t0 + M_cycles_2/fin_2; vssa = 0; vdda = 1.8; v_ref = vdda; v_cm = 0.9; t_sim = t_start + t_drop + (t1-t0) + 1/fs
    Outputs: /vp; /vn; /result<7:0>; /valid; /clk; /en; /rstn; /cal; /I0/cdac_pout; /I0/cdac_nout; codes; (codes * 2); (dft codes); fft_codes; t0; vin; fft_vin; spectrumMeasurement(codes t VAR("t0") VAR("t1") VAR("Nfft") 0 50000 0 "Rectangular" 0 0 1 "enob"); spectrumMeasurement(codes t VAR("t0") VAR("t1") VAR("Nfft") 0 50000 0 "Rectangular" 0 0 1 "thd"); spectrumMeasurement(codes t VAR("t0") VAR("t1") VAR("Nfft") 0 50000 0 "Rectangular" 0 0 1 "snhr"); spectrumMeasurement(codes t VAR("t0") VAR("t1") VAR("Nfft") 0 50000 0 "Rectangular" 0 0 1 "afdr"); sfdr_codes; /vout; fft_vout; sfdr_vout; f1_vout; f2_vout; f_diff_vout; f_sum_vout; (10 * log10(rms("v+"))); IMD_vout
Global variables:
  vdd = 1.8
  vss = 0
