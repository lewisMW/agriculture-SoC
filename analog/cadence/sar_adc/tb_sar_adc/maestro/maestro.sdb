ADE simulation setup
Run mode: Single Run, Sweeps and Corners
Tests:
  sar_adc_tb_sar_adc_1: sar_adc/tb_sar_adc/config, simulator ams
    Variables: vdd_supply = 1.8; vss_supply = 0; fclk = 1000000
    Outputs: /vp; /vn; /result<7:0>; /valid; /clk; /en; /rstn; /cal; /I0/cdac_pout; /I0/cdac_nout
  sar_adc_sine_fft: sar_adc/tb_sar_adc/config, simulator spectre
    Variables: fs = fclk/10; fclk = 1000000; Nfft = 1024; M_cycles = 31; fin_1 = fs*M_cycles/Nfft; N_drop = 2; t_drop = N_drop/fs; t_start = 16.5u; t0 = t_start + t_drop + 5u; t1 = t0 + M_cycles/fin_1; vssa = 0; vdda = 1.8; v_ref = 1.6993 1.6043 1.4298 1.2743 0.9021 0.5692 0.18 0.0569 0.018 0.0057 0.0018; v_cm = 0.9; t_sim = t_start + t_drop + (t1-t0) + 1/fs; fin_2 = 0; v1 = v_ref/2; v2 = 0; tstep = (t1-t0)/Nfft
    Outputs: /vp; /vn; /result<7:0>; /valid; /clk; /en; /rstn; /cal; /I0/cdac_pout; /I0/cdac_nout; codes; (codes * 2); (dft codes); vin; enob; spectrumMeasurement(codes t VAR("t0") VAR("t1") VAR("Nfft") 0 50000 0 "Rectangular" 0 0 1 "enob"); thd; spectrumMeasurement(codes t VAR("t0") VAR("t1") VAR("Nfft") 0 50000 0 "Rectangular" 0 0 1 "thd"); spectrumMeasurement(codes t VAR("t0") VAR("t1") VAR("Nfft") 0 50000 0 "Rectangular" 0 0 1 "snhr"); spectrumMeasurement(codes t VAR("t0") VAR("t1") VAR("Nfft") 0 50000 0 "Rectangular" 0 0 1 "afdr"); sfdr; snr; /vout; sinad; fft_vout; sigpower; vout; H1; H3; H5; H7; samples
  sar_adc_sine_two_tone: sar_adc/tb_sar_adc/config, simulator spectre
    Variables: fs = fclk/10; fclk = 1000000; Nfft = 1024; M_cycles_1 = 31 61 97 127 157 191 223 257 283 317 353 383 419 449 479 499; M_cycles_2 = M_cycles_1+8; fin_1 = fs*M_cycles_1/Nfft; fin_2 = fs*M_cycles_2/Nfft; N_drop = 2; t_drop = N_drop/fs; t_start = 16.5u; t0 = t_start + t_drop + 5u; t1 = t0 + M_cycles_2/fin_2; vssa = 0; vdda = 1.8; v_ref = 0.9; v_cm = 0.9; t_sim = t_start + t_drop + (t1-t0) + 1/fs; v1 = v_ref/2; v2 = v_ref/2
    Outputs: /vp; /vn; /result<7:0>; /valid; /clk; /en; /rstn; /cal; /I0/cdac_pout; /I0/cdac_nout; codes; (codes * 2); (dft codes); t0; vin; fft_vin; spectrumMeasurement(codes t VAR("t0") VAR("t1") VAR("Nfft") 0 50000 0 "Rectangular" 0 0 1 "enob"); spectrumMeasurement(codes t VAR("t0") VAR("t1") VAR("Nfft") 0 50000 0 "Rectangular" 0 0 1 "thd"); spectrumMeasurement(codes t VAR("t0") VAR("t1") VAR("Nfft") 0 50000 0 "Rectangular" 0 0 1 "snhr"); spectrumMeasurement(codes t VAR("t0") VAR("t1") VAR("Nfft") 0 50000 0 "Rectangular" 0 0 1 "afdr"); /vout; fft_vout; V1; V2; Vmin; Vplus; (10 * log10(rms("v+"))); IMD2; fplus; fmin; vout; IMD2_floor; f3low; f3high; V3low; V3high; IMD3; bin; spec; tone; SFDR_2TONE; spur
  sar_adc_sine_hist: sar_adc/tb_sar_adc/config, simulator spectre
    Variables: fs = fclk/10; fclk = 1000000; Nfft = 1024; M_cycles = 31; fin_1 = fs*M_cycles/Nfft; N_drop = 2; t_drop = N_drop/fs; t_start = 16.5u; t0 = t_start + t_drop + 5u; t1 = t0 + M_cycles/fin_1; vssa = 0; vdda = 1.8; v_ref = 1.81; v_cm = 0.9; t_sim = t_start + t_drop + (t1-t0) + 1/fs; fin_2 = 0; Nfft_real = 2**18; M_cycles_real = 7873; v1 = v_ref/2; v2 = 0; tstep = (t1-t0)/Nfft
    Outputs: /vp; /vn; /result<7:0>; /valid; /clk; /en; /rstn; /cal; /I0/cdac_pout; /I0/cdac_nout; codes; (codes * 2); (dft codes); t0; vin; spectrumMeasurement(codes t VAR("t0") VAR("t1") VAR("Nfft") 0 50000 0 "Rectangular" 0 0 1 "enob"); spectrumMeasurement(codes t VAR("t0") VAR("t1") VAR("Nfft") 0 50000 0 "Rectangular" 0 0 1 "thd"); spectrumMeasurement(codes t VAR("t0") VAR("t1") VAR("Nfft") 0 50000 0 "Rectangular" 0 0 1 "snhr"); spectrumMeasurement(codes t VAR("t0") VAR("t1") VAR("Nfft") 0 50000 0 "Rectangular" 0 0 1 "afdr"); /vout; sample(codes VT("/t0") VT("/t1") "linear" 1e-05); sample(codes VT("t0") VT("t1") "linear" 1e-05); samples; vout; sum; integ(hist_cum -1 1 nil); integ(hist_cum -0.9 0.9 nil); integ(hist_cum -0.9 nil)
Global variables:
  vdd = 1.8
  vss = 0
