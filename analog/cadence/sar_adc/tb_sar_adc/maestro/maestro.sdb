ADE simulation setup
Run mode: Single Run, Sweeps and Corners
Tests:
  sar_adc_tb_sar_adc_1: sar_adc/tb_sar_adc/config, simulator ams
    Variables: vdd_supply = 1.8; vss_supply = 0; fclk = 1000000
    Outputs: /vp; /vn; /result<7:0>; /valid; /clk; /en; /rstn; /cal; /I0/cdac_pout; /I0/cdac_nout
Global variables:
  vdd = 1.8
  vss = 0
