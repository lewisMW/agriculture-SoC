ADE simulation setup
Test sar_adc_tb_sar_adc_1: sar_adc/tb_sar_adc/config, simulator ams
  Models: /home/jaime/sky130_release_0.1.0/models/sky130.lib.spice[tt]
  Variables: vdd_supply = 1.8; vss_supply = 0; fclk = 1000000
  Temperature: 27
  Stimulus vn: voltage dc dc=vss_supply srcType=dc
  Stimulus vdda: voltage dc dc=vdd_supply srcType=dc
  Stimulus vp: voltage pulse val0=vss_supply val1=vdd_supply delay=5*1/fclk rise=1m fall=10n srcType=pulse
  Stimulus vdd: voltage dc dc=vdd_supply srcType=dc
  Stimulus vss: voltage dc dc=vss_supply srcType=dc
  Stimulus vssa: voltage dc dc=vss_supply srcType=dc
  Analysis tran: stop=1m
  Signals: /vp, /vn, /result<7:0>, /valid, /clk, /en, /rstn, /cal
Test sar_adc_sine_test: sar_adc/tb_sar_adc/config, simulator spectre
  Models: /opt/pdk/cadence_SKY130/sky130_release_0.1.0/libs/sky130_fd_pr_main/../../models/sky130.lib.spice[tt]
  Variables: vdda = 1.8; fclk = 1000000; N_fft = 1024; M_cycles = 31; t0 = 100.5u; vssa = 0; v_cm = 0.9; fs = fclk/10; v_ref = vdda; fin = fs*M_cycles/N_fft; t1 = t0 + N_fft/fs; t_sim = 1.1*t1
  Temperature: 27
  Stimulus vp: voltage sin dc=vcm mag=vsin delay=5*1/fclk freq=fin filenums=none srcType=sine
  Stimulus vn: voltage dc dc=vss_supply srcType=dc
  Stimulus vdda: voltage dc dc=vdd_supply srcType=dc
  Stimulus vdd: voltage dc dc=vdd_supply srcType=dc
  Stimulus vssa: voltage dc dc=vss_supply srcType=dc
  Stimulus vss: voltage dc dc=vss_supply srcType=dc
  Analysis tran: stop=VAR("tsim")
  Output codes = ((VT("/result<0>") + (2 * VT("/result<1>")) + (4 * VT("/result<2>")) + (8 * VT("/result<3>")) + (16 * VT("/result<4>")) + (32 * VT("/result<5>")) + (64 * VT("/result<6>")) + (128 * VT("/result<7>"))) / 1.8)
  Output fft = dft(codes t0 t1 N_fft "Rectangular")
  Output histogram2D(codes 10 "standard" nil nil)
  Signals: /vp, /vn, /result<7:0>, /valid, /clk, /en, /rstn, /cal
Test sar_adc_sine_linearity: sar_adc/tb_sar_adc/schematic, simulator spectre
  Models: /opt/pdk/cadence_SKY130/sky130_release_0.1.0/libs/sky130_fd_pr_main/../../models/sky130.lib.spice[tt]
  Temperature: 27
Test sar_adc_sine_fft: sar_adc/tb_sar_adc/config, simulator spectre
  Models: /opt/pdk/cadence_SKY130/sky130_release_0.1.0/libs/sky130_fd_pr_main/../../models/sky130.lib.spice[tt]
  Variables: fclk = 1000000; Nfft = 1024; M_cycles = 31; N_drop = 2; t_start = 16.5u; vssa = 0; vdda = 1.8; v_cm = 0.9; fin_2 = 0; v_ref = 1.6993 1.6043 1.4298 1.2743 0.9021 0.5692 0.18 0.0569 0.018 0.0057 0.0018; v2 = 0; fs = fclk/10; v1 = v_ref/2; fin_1 = fs*M_cycles/Nfft; t_drop = N_drop/fs; t0 = t_start + t_drop + 5u; t1 = t0 + M_cycles/fin_1; t_sim = t_start + t_drop + (t1-t0) + 1/fs; tstep = (t1-t0)/Nfft
  Temperature: 27
  Stimulus vp: voltage sin dc=v_cm delay=5*1/fclk ampl=v1 freq=fin_1 ampl2=v2 freq2=fin_2 filenums=none srcType=sine
  Stimulus vn: voltage sin dc=v_cm delay=5*1/fclk ampl=v1 sinephase=180 freq=fin_1 ampl2=v2 sinephase2=180 freq2=fin_2 filenums=none srcType=sine
  Stimulus vdda: voltage dc dc=vdda srcType=dc
  Stimulus vdd: voltage dc dc=vdda srcType=dc
  Stimulus vssa: voltage dc dc=vssa srcType=dc
  Stimulus vss: voltage dc dc=vssa srcType=dc
  Analysis tran: stop=VAR("t_sim")
  Output vin = (VT("/vp") - VT("/vn"))
  Output codes = ((VT("/result<0>") + (2 * VT("/result<1>")) + (4 * VT("/result<2>")) + (8 * VT("/result<3>")) + (16 * VT("/result<4>")) + (32 * VT("/result<5>")) + (64 * VT("/result<6>")) + (128 * VT("/result<7>"))) / 1.8)
  Output vout = VT("/vout")
  Output fft_vout = dft(vout VAR("t0") VAR("t1") VAR("Nfft") "Rectangular" 1 "default" 1.0)
  Output samples = sample(vout VAR("t0") (VAR("t1") - VAR("tstep")) "linear" VAR("tstep"))
  Output sinad = spectrumMeasurement(vout t VAR("t0") VAR("t1") VAR("Nfft") 0 50000.0 0 "Rectangular" 0 0 2 "sinad")
  Output enob = spectrumMeasurement(vout t VAR("t0") VAR("t1") VAR("Nfft") 0 50000 0 "Rectangular" 0 0 2 "enob")
  Output thd = spectrumMeasurement(vout t VAR("t0") VAR("t1") VAR("Nfft") 0 50000 0 "Rectangular" 0 0 6 "thd")
  Output sfdr = spectrumMeasurement(vout t VAR("t0") VAR("t1") VAR("Nfft") 0 50000 0 "Rectangular" 0 0 2 "sfdr")
  Output snr = spectrumMeasurement(vout t VAR("t0") VAR("t1") VAR("Nfft") 0 50000 0 "Rectangular" 0 0 2 "snr")
  Output sigpower = spectrumMeasurement(vout t VAR("t0") VAR("t1") VAR("Nfft") 0 50000 0 "Rectangular" 0 0 2 "sigpower")
  Output H1 = abs(value(fft_vout VAR("fin_1")))
  Output H3 = (abs(value(fft_vout (3 * VAR("fin_1")))) / H1)
  Output H5 = (abs(value(fft_vout (5 * VAR("fin_1")))) / H1)
  Output H7 = (abs(value(fft_vout (7 * VAR("fin_1")))) / H1)
  Signals: /vp, /vn, /result<7:0>, /valid, /clk, /en, /rstn, /cal, /vout
Test sar_adc_sine_two_tone: sar_adc/tb_sar_adc/config, simulator spectre
  Models: /opt/pdk/cadence_SKY130/sky130_release_0.1.0/libs/sky130_fd_pr_main/../../models/sky130.lib.spice[tt]
  Variables: fclk = 1000000; Nfft = 1024; M_cycles_1 = 31 61 97 127 157 191 223 257 283 317 353 383 419 449 479 499; N_drop = 2; t_start = 16.5u; vssa = 0; vdda = 1.8; v_cm = 0.9; v_ref = 0.9; M_cycles_2 = M_cycles_1+8; fs = fclk/10; v1 = v_ref/2; v2 = v_ref/2; fin_1 = fs*M_cycles_1/Nfft; fin_2 = fs*M_cycles_2/Nfft; t_drop = N_drop/fs; t0 = t_start + t_drop + 5u; t1 = t0 + M_cycles_2/fin_2; t_sim = t_start + t_drop + (t1-t0) + 1/fs
  Temperature: 27
  Stimulus vp: voltage sin dc=v_cm delay=5*1/fclk ampl=v1 freq=fin_1 ampl2=v2 freq2=fin_2 filenums=none srcType=sine
  Stimulus vn: voltage sin dc=v_cm delay=5*1/fclk ampl=v1 sinephase=180 freq=fin_1 ampl2=v2 sinephase2=180 freq2=fin_2 filenums=none srcType=sine
  Stimulus vdda: voltage dc dc=vdda srcType=dc
  Stimulus vdd: voltage dc dc=vdda srcType=dc
  Stimulus vssa: voltage dc dc=vssa srcType=dc
  Stimulus vss: voltage dc dc=vssa srcType=dc
  Analysis tran: stop=VAR("t_sim")
  Output vin = (VT("/vp") - VT("/vn"))
  Output vout = VT("/vout")
  Output codes = ((VT("/result<0>") + (2 * VT("/result<1>")) + (4 * VT("/result<2>")) + (8 * VT("/result<3>")) + (16 * VT("/result<4>")) + (32 * VT("/result<5>")) + (64 * VT("/result<6>")) + (128 * VT("/result<7>"))) / 1.8)
  Output fft_vin = dft(vin VAR("t0") VAR("t1") VAR("Nfft") "Rectangular" 1 "default" 1.0)
  Output fft_vout = dft(vout VAR("t0") VAR("t1") VAR("Nfft") "Rectangular" 1 "default" 1.0)
  Output V1 = rms(abs(value(fft_vout VAR("fin_1"))))
  Output V2 = rms(abs(value(fft_vout VAR("fin_2"))))
  Output fplus = min((VAR("fin_1") + VAR("fin_2")) (VAR("fs") - VAR("fin_1") - VAR("fin_2")))
  Output fmin = (VAR("fin_2") - VAR("fin_1"))
  Output Vplus = rms(abs(value(fft_vout fplus)))
  Output Vmin = rms(abs(value(fft_vout fmin)))
  Output IMD2 = (10 * log10((max(((Vplus**2) + (Vmin**2)) 1e-12) / ((V1**2) + (V2**2)))))
  Output IMD2_floor = (10 * log10((1e-12 / ((V1**2) + (V2**2)))))
  Output f3low = ((2 * VAR("fin_1")) - VAR("fin_2"))
  Output f3high = min(((2 * VAR("fin_2")) - VAR("fin_1")) ((VAR("fs") - (2 * VAR("fin_2"))) + VAR("fin_1")))
  Output V3low = rms(abs(value(fft_vout f3low)))
  Output V3high = rms(abs(value(fft_vout f3high)))
  Output IMD3 = (10 * log10((((V3high**2) + (V3low**2)) / ((V1**2) + (V2**2)))))
  Output bin = (VAR("fs") / VAR("Nfft"))
  Output spec = abs(fft_vout)
  Output tone = max(value(spec VAR("fin_1")) value(spec VAR("fin_2")))
  Output spur = max(ymax(clip(spec bin (VAR("fin_1") - bin))) ymax(clip(spec (VAR("fin_1") + bin) (VAR("fin_2") - bin))) ymax(clip(spec (VAR("fin_2") + bin) (VAR("fs") / 2))))
  Output SFDR_2TONE = dB20((tone / spur))
  Signals: /vp, /vn, /result<7:0>, /valid, /clk, /en, /rstn, /cal, /vout
Test sar_adc_sine_hist: sar_adc/tb_sar_adc/config, simulator spectre
  Models: /opt/pdk/cadence_SKY130/sky130_release_0.1.0/libs/sky130_fd_pr_main/../../models/sky130.lib.spice[tt]
  Variables: fclk = 1000000; Nfft = 1024; M_cycles = 31; N_drop = 2; t_start = 16.5u; vssa = 0; vdda = 1.8; v_ref = 1.81; v_cm = 0.9; fin_2 = 0; Nfft_real = 2**18; M_cycles_real = 7873; v2 = 0; fs = fclk/10; v1 = v_ref/2; fin_1 = fs*M_cycles/Nfft; t_drop = N_drop/fs; t0 = t_start + t_drop + 5u; t1 = t0 + M_cycles/fin_1; t_sim = t_start + t_drop + (t1-t0) + 1/fs; tstep = (t1-t0)/Nfft
  Temperature: 27
  Stimulus vp: voltage sin dc=v_cm delay=5*1/fclk ampl=v1 freq=fin_1 ampl2=v2 freq2=fin_2 filenums=none srcType=sine
  Stimulus vn: voltage sin dc=v_cm delay=5*1/fclk ampl=v1 sinephase=180 freq=fin_1 ampl2=v2 sinephase2=180 freq2=fin_2 filenums=none srcType=sine
  Stimulus vdda: voltage dc dc=vdda srcType=dc
  Stimulus vdd: voltage dc dc=vdda srcType=dc
  Stimulus vssa: voltage dc dc=vssa srcType=dc
  Stimulus vss: voltage dc dc=vssa srcType=dc
  Analysis tran: stop=VAR("t_sim")
  Output vin = (VT("/vp") - VT("/vn"))
  Output vout = VT("/vout")
  Output codes = ((VT("/result<0>") + (2 * VT("/result<1>")) + (4 * VT("/result<2>")) + (8 * VT("/result<3>")) + (16 * VT("/result<4>")) + (32 * VT("/result<5>")) + (64 * VT("/result<6>")) + (128 * VT("/result<7>"))) / 1.8)
  Output samples = sample(vout VAR("t0") (VAR("t1") - VAR("tstep")) "linear" VAR("tstep"))
  Signals: /vp, /vn, /result<7:0>, /valid, /clk, /en, /rstn, /cal, /vout
