ADE simulation setup
Test sar_adc_tb_sar_adc_1: sar_adc/tb_sar_adc/config, simulator ams
  Models: /opt/pdk/sky130_release_0.1.0/models/sky130.lib.spice[tt]
  Variables: vdd_supply = 1.8; vss_supply = 0; fclk = 1000000
  Temperature: 27
  Stimulus vn: voltage dc dc=vss_supply srcType=dc
  Stimulus vdda: voltage dc dc=vdd_supply srcType=dc
  Stimulus vp: voltage pulse val0=vss_supply val1=vdd_supply delay=5*1/fclk rise=1m fall=10n srcType=pulse
  Stimulus vdd: voltage dc dc=vdd_supply srcType=dc
  Stimulus vss: voltage dc dc=vss_supply srcType=dc
  Stimulus vssa: voltage dc dc=vss_supply srcType=dc
  Analysis tran: stop=1m
  Signals: /vp, /vn, /result<7:0>, /valid, /clk, /en, /rstn, /cal, /I0/cdac_pout, /I0/cdac_nout
Run mode: Single Run, Sweeps and Corners
Global variables:
  vdd = 1.8
  vss = 0
