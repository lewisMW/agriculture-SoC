ADE simulation setup
Test sar_adc_tb_sar_adc_1: sar_adc/tb_sar_adc/config, simulator ams
  Models: /home/jaime/sky130_release_0.1.0/models/sky130.lib.spice[tt]
  Variables: vdd_supply = 1.8; vss_supply = 0; fclk = 1000000
  Temperature: 27
  Stimulus vn: voltage dc dc=vss_supply srcType=dc
  Stimulus vdda: voltage dc dc=vdd_supply srcType=dc
  Stimulus vp: voltage pulse val0=vss_supply val1=vdd_supply delay=5*1/fclk rise=1m fall=10n srcType=pulse
  Stimulus vdd: voltage dc dc=vdd_supply srcType=dc
  Stimulus vss: voltage dc dc=vss_supply srcType=dc
  Stimulus vssa: voltage dc dc=vss_supply srcType=dc
  Analysis tran: stop=1m
  Signals: /vp, /vn, /result<7:0>, /valid, /clk, /en, /rstn, /cal
Test sar_adc_sine_test: sar_adc/tb_sar_adc/config, simulator spectre
  Models: /opt/pdk/cadence_SKY130/sky130_release_0.1.0/libs/sky130_fd_pr_main/../../models/sky130.lib.spice[tt]
  Variables: vdda = 1.8; fclk = 1000000; N_fft = 1024; M_cycles = 31; t0 = 100.5u; vssa = 0; v_cm = 0.9; fs = fclk/10; v_ref = vdda; fin = fs*M_cycles/N_fft; t1 = t0 + N_fft/fs; t_sim = 1.1*t1
  Temperature: 27
  Stimulus vp: voltage sin dc=vcm mag=vsin delay=5*1/fclk freq=fin filenums=none srcType=sine
  Stimulus vn: voltage dc dc=vss_supply srcType=dc
  Stimulus vdda: voltage dc dc=vdd_supply srcType=dc
  Stimulus vdd: voltage dc dc=vdd_supply srcType=dc
  Stimulus vssa: voltage dc dc=vss_supply srcType=dc
  Stimulus vss: voltage dc dc=vss_supply srcType=dc
  Analysis tran: stop=VAR("tsim")
  Output codes = ((VT("/result<0>") + (2 * VT("/result<1>")) + (4 * VT("/result<2>")) + (8 * VT("/result<3>")) + (16 * VT("/result<4>")) + (32 * VT("/result<5>")) + (64 * VT("/result<6>")) + (128 * VT("/result<7>"))) / 1.8)
  Output fft = dft(codes t0 t1 N_fft "Rectangular")
  Output histogram2D(codes 10 "standard" nil nil)
  Signals: /vp, /vn, /result<7:0>, /valid, /clk, /en, /rstn, /cal
Test sar_adc_sine_linearity: sar_adc/tb_sar_adc/schematic, simulator spectre
  Models: /opt/pdk/cadence_SKY130/sky130_release_0.1.0/libs/sky130_fd_pr_main/../../models/sky130.lib.spice[tt]
  Temperature: 27
Test sar_adc_sine_fft: sar_adc/tb_sar_adc/config, simulator spectre
  Models: /opt/pdk/cadence_SKY130/sky130_release_0.1.0/libs/sky130_fd_pr_main/../../models/sky130.lib.spice[tt]
  Variables: fclk = 1000000; Nfft = 1024; M_cycles = 31; N_drop = 2; t_start = 100.5u; vssa = 0; vdda = 1.8; v_cm = 0.9; fin_2 = 0; fs = fclk/10; v_ref = vdda; fin_1 = fs*M_cycles/Nfft; t_drop = N_drop/fs; t0 = t_start + t_drop; t1 = t0 + M_cycles/fin_1; t_sim = t_start + t_drop + (t1-t0) + 1/fs
  Temperature: 27
  Stimulus vp: voltage sin dc=v_cm mag=v_ref/2 delay=5*1/fclk freq=fin_1 freq2=fin_2 filenums=none srcType=sine
  Stimulus vn: voltage sin dc=v_cm mag=v_ref/2 delay=5*1/fclk sinephase=180 freq=fin_1 sinephase2=180 freq2=fin_2 filenums=none srcType=sine
  Stimulus vdda: voltage dc dc=vdda srcType=dc
  Stimulus vdd: voltage dc dc=vdda srcType=dc
  Stimulus vssa: voltage dc dc=vssa srcType=dc
  Stimulus vss: voltage dc dc=vssa srcType=dc
  Analysis tran: stop=VAR("t_sim")
  Output vin = (VT("/vp") - VT("/vn"))
  Output fft_vin = dft(vin VAR("t0") VAR("t1") VAR("Nfft") "Rectangular" 1 "default" 1.0) (unticked)
  Output codes = ((VT("/result<0>") + (2 * VT("/result<1>")) + (4 * VT("/result<2>")) + (8 * VT("/result<3>")) + (16 * VT("/result<4>")) + (32 * VT("/result<5>")) + (64 * VT("/result<6>")) + (128 * VT("/result<7>"))) / 1.8)
  Output fft_codes = dft(codes VAR("t0") VAR("t1") VAR("Nfft") "Rectangular" 1 "default" 1.0)
  Output sinad_codes = spectrumMeasurement(codes t VAR("t0") VAR("t1") VAR("Nfft") 0 50000.0 0 "Rectangular" 0 0 2 "sinad")
  Output enob = spectrumMeasurement(codes t VAR("t0") VAR("t1") VAR("Nfft") 0 50000 0 "Rectangular" 0 0 2 "enob")
  Output thd = spectrumMeasurement(codes t VAR("t0") VAR("t1") VAR("Nfft") 0 50000 0 "Rectangular" 0 0 5 "thd")
  Output sfdr = spectrumMeasurement(codes t VAR("t0") VAR("t1") VAR("Nfft") 0 50000 0 "Rectangular" 0 0 2 "sfdr")
  Output snr = spectrumMeasurement(codes t VAR("t0") VAR("t1") VAR("Nfft") 0 50000 0 "Rectangular" 0 0 2 "snr")
  Output sinad_vout = spectrumMeasurement(VT("/vout") t VAR("t0") VAR("t1") VAR("Nfft") 0 50000.0 0 "Rectangular" 0 0 2 "sinad")
  Output fft_vout = dft(VT("/vout") VAR("t0") VAR("t1") VAR("Nfft") "Rectangular" 1 "default" 1.0)
  Output sigpower = spectrumMeasurement(codes t VAR("t0") VAR("t1") VAR("Nfft") 0 50000 0 "Rectangular" 0 0 2 "sigpower")
  Signals: /vp, /vn, /result<7:0>, /valid, /clk, /en, /rstn, /cal, /vout
Test sar_adc_sine_two_tone: sar_adc/tb_sar_adc/config, simulator spectre
  Models: /opt/pdk/cadence_SKY130/sky130_release_0.1.0/libs/sky130_fd_pr_main/../../models/sky130.lib.spice[tt]
  Variables: fclk = 1000000; Nfft = 1024; M_cycles_1 = 59; M_cycles_2 = 67; N_drop = 2; t_start = 100.5u; vssa = 0; vdda = 1.8; v_cm = 0.9; fs = fclk/10; v_ref = vdda; fin_1 = fs*M_cycles_1/Nfft; fin_2 = fs*M_cycles_2/Nfft; t_drop = N_drop/fs; t0 = t_start + t_drop; t1 = t0 + M_cycles_2/fin_2; t_sim = t_start + t_drop + (t1-t0) + 1/fs
  Temperature: 27
  Stimulus vp: voltage sin dc=v_cm mag=v_ref/2 delay=5*1/fclk freq=fin_1 freq2=fin_2 filenums=none srcType=sine
  Stimulus vn: voltage sin dc=v_cm mag=v_ref/2 delay=5*1/fclk sinephase=180 freq=fin_1 sinephase2=180 freq2=fin_2 filenums=none srcType=sine
  Stimulus vdda: voltage dc dc=vdda srcType=dc
  Stimulus vdd: voltage dc dc=vdda srcType=dc
  Stimulus vssa: voltage dc dc=vssa srcType=dc
  Stimulus vss: voltage dc dc=vssa srcType=dc
  Analysis tran: stop=VAR("t_sim")
  Output vin = (VT("/vp") - VT("/vn"))
  Output codes = ((VT("/result<0>") + (2 * VT("/result<1>")) + (4 * VT("/result<2>")) + (8 * VT("/result<3>")) + (16 * VT("/result<4>")) + (32 * VT("/result<5>")) + (64 * VT("/result<6>")) + (128 * VT("/result<7>"))) / 1.8) (unticked)
  Output fft_vin = dft(vin VAR("t0") VAR("t1") VAR("Nfft") "Rectangular" 1 "default" 1.0) (unticked)
  Output fft_vout = dft(VT("/vout") VAR("t0") VAR("t1") VAR("Nfft") "Rectangular" 1 "default" 1.0)
  Output fft_codes = dft(codes VAR("t0") VAR("t1") VAR("Nfft") "Rectangular" 1 "default" 1.0)
  Output sfdr_codes = spectrumMeasurement(codes t VAR("t0") VAR("t1") VAR("Nfft") 0 50000 0 "Rectangular" 0 0 2 "sfdr")
  Output sfdr_vout = spectrumMeasurement(VT("/vout") t VAR("t0") VAR("t1") VAR("Nfft") 0 50000 0 "Rectangular" 0 0 2 "sfdr")
  Output f1_vout = abs(value(fft_vout VAR("fin_1")))
  Output f2_vout = abs(value(fft_vout VAR("fin_2")))
  Output f_diff_vout = real(value(fft_vout (f2_vout - f1_vout)))
  Output f_sum_vout = real(value(fft_vout (f2_vout + f1_vout)))
  Output IMD_vout = (10 * log10((((rms(f_diff_vout)**2) + (rms(f_sum_vout)**2)) / ((rms(VT("/vp"))**2) + rms(VT("/vn"))))))
  Signals: /vp, /vn, /result<7:0>, /valid, /clk, /en, /rstn, /cal, /vout
