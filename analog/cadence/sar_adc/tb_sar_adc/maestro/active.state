ADE simulation setup
Test sar_adc_tb_sar_adc_1: sar_adc/tb_sar_adc/config, simulator ams
  Models: /opt/pdk/sky130_release_0.1.0/models/sky130.lib.spice[tt]
  Variables: vdd = 1.8; vss = 0
  Temperature: 27
  Stimulus vp: voltage pulse val0=vss val1=vdd delay=10u rise=10m fall=10n srcType=pulse
  Stimulus vn: voltage dc dc=vss srcType=dc
  Stimulus cal: voltage bit val1=vdd val0=vss rise=10n fall=10n period=1u srcType=bit data=000000000000
  Stimulus clk: voltage pulse dc=vdd/2 mag=vdd/2 val0=0 val1=0 period=1u rise=10n fall=10n edgetype=linear srcType=pulse
  Stimulus en: voltage bit val1=vdd val0=vss rise=10n fall=10n period=1u srcType=bit data=001000000000
  Stimulus rstn: voltage bit val1=vdd val0=vss rise=10n fall=10n period=1u srcType=bit data=010000000000
  Analysis tran: stop=10m
  Signals: /vp, /vn, /result<7:0>, /valid, /clk, /en, /rstn, /cal
Run mode: Single Run, Sweeps and Corners
Global variables:
  vdd = 1.8
  vss = 0
Setup values for test sar_adc_tb_sar_adc_1: vdd_supply = 1.8; vss_supply = 0; fclk = 1000000
