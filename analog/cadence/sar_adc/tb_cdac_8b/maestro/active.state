ADE simulation setup
Test adc_tb_lib_tb_cdac_8b_1: adc_tb_lib/tb_cdac_8b/auto_config, simulator ams
  Variables: VCC = 1.8; Cu = 1e-15; Vin_mid = 0.9; Vin_low = 0.45; Vin_high = 1.6; T_sample = 100e-9; T_settle = 50e-09; T_sar_step = 50e-09
  Temperature: 27
  Analysis tran: stop=130u
  Signals: /vout, /vin, /sample, /ctl_dum, /ctrl<7:0>
Run mode: Single Run, Sweeps and Corners
