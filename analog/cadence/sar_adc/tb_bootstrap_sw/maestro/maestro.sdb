ADE simulation setup
Run mode: Single Run, Sweeps and Corners
Tests:
  bootstrap_switch_lib_bootstrap_sw_tb_1: sar_adc/tb_bootstrap_sw/config, simulator spectre
    Variables: vin = 1
    Outputs: /vin; /vout; /en; /C0/PLUS; /bs_switch/vbsh; /bs_switch/vbsl
