ADE simulation setup
Test Reset_op: sar_adc/tb_comparator_parasitic/schematic, simulator spectre
  Models: /home/admin/Documents/PDKs/sky130_release_0.1.0/models/sky130.lib.spice[tt]
  Variables: ncyc = 6; vos = 0; pol = -1; tsu = 0.5n; vagg = 300m; nrep = 1; nsteps = 61; vstep = 1m; vstart = -30m; mode = 0; cload = 10f; ccdac = 9.3p; rs = 1; trim_b = 8; trim_a = 8; tf = 100p; tr = 100p; duty = 0.5; fclk = 1M; vd = 100m; vcm = 0.9; vcc = 1.8; tstop = (ncyc+1)/fclk
  Temperature: 27
  Simulator options: reltol=1e-5
  Files: definitions /home/admin/Documents/Erick_dev_git_copy/agriculture-SoC/analog/cadence/verif_comparator/tbcmp_stim.scs
  Analysis tran: stop=VAR("tstop") errpreset=moderate
  Output outp_rst = (value(VT("/outp") ((3.5 / VAR("fclk")) - 1e-09)) / VAR("vcc"))
  Output outn_rst = (value(VT("/outn") ((3.5 / VAR("fclk")) - 1e-09)) / VAR("vcc"))
  Output net2_rst = (value(VT("/I0/XCORE/net2") ((3.5 / VAR("fclk")) - 1e-09)) / VAR("vcc"))
  Output net3_rst = (value(VT("/I0/XCORE/net3") ((3.5 / VAR("fclk")) - 1e-09)) / VAR("vcc"))
  Output t_reset = delay(?wf1 VT("/clk") ?value1 (VAR("vcc") / 2) ?edge1 "falling" ?nth1 3 ?wf2 abs((VT("/outp") - VT("/outn"))) ?value2 (0.1 * VAR("vcc")) ?edge2 "falling" ?nth2 3)
  Output t_reset_frac = ((delay(?wf1 VT("/clk") ?value1 (VAR("vcc") / 2) ?edge1 "falling" ?nth1 3 ?wf2 abs((VT("/outp") - VT("/outn"))) ?value2 (0.1 * VAR("vcc")) ?edge2 "falling" ?nth2 3) * VAR("fclk")) / (1 - VAR("duty")))
Test Common_mode: sar_adc/tb_comparator_parasitic/schematic, simulator spectre
  Models: /home/admin/Documents/PDKs/sky130_release_0.1.0/models/sky130.lib.spice[tt]
  Variables: vos = 0; pol = -1; tsu = 0.5n; vagg = 300m; nrep = 1; nsteps = 61; vstep = 1m; vstart = -30m; mode = 1; cload = 10f; ccdac = 9.3p; rs = 1; trim_b = 8; trim_a = 8; tf = 100p; tr = 100p; duty = 0.5; fclk = 1M; vd = 10m; vcm = 0.3 0.5 0.7 0.9 1.1 1.3 1.5; vcc = 1.8; ncyc = nsteps*nrep; tstop = (ncyc+1)/fclk
  Temperature: 27
  Simulator options: reltol=1e-5
  Files: definitions /home/admin/Documents/Erick_dev_git_copy/agriculture-SoC/analog/cadence/verif_comparator/tbcmp_stim.scs
  Analysis tran: stop=VAR("tstop") errpreset=moderate
  Output Vos = tbcmp_vos(VT("/outp") VT("/outn") VAR("fclk") VAR("duty") VAR("tsu") VAR("vstart") VAR("vstep") VAR("nsteps") VAR("nrep") VAR("vcc") VAR("pol"))
  Output t_cq = delay(?wf1 VT("/clk") ?value1 (VAR("vcc") / 2) ?edge1 "rising" ?nth1 4 ?wf2 abs((VT("/outp") - VT("/outn"))) ?value2 (VAR("vcc") / 2) ?edge2 "rising" ?nth2 4)
  Output n_wrong = tbcmp_count(VT("/outp") VT("/outn") VAR("fclk") VAR("duty") VAR("tsu") VAR("mode") VAR("vd") VAR("vstart") VAR("vstep") VAR("nrep") VAR("ncyc") VAR("vos") VAR("vcc") VAR("pol") "wrong")
  Output n_unres = tbcmp_count(VT("/outp") VT("/outn") VAR("fclk") VAR("duty") VAR("tsu") VAR("mode") VAR("vd") VAR("vstart") VAR("vstep") VAR("nrep") VAR("ncyc") VAR("vos") VAR("vcc") VAR("pol") "unresolved")
Test Kickback: sar_adc/tb_comparator_parasitic/schematic, simulator spectre
  Models: /home/admin/Documents/PDKs/sky130_release_0.1.0/models/sky130.lib.spice[tt]
  Variables: ncyc = 8; vos = 0; pol = -1; tsu = 0.5n; vagg = 300m; nrep = 1; nsteps = 61; vstep = 1m; vstart = -30m; mode = 0; cload = 10f; ccdac = 9.3p 1p 100f; rs = 1G; trim_b = 8; trim_a = 8; tf = 100p; tr = 100p; duty = 0.5; fclk = 1M; vd = 1m 100m; vcm = 0.9; vcc = 1.8; tstop = (ncyc+1)/fclk
  Temperature: 27
  Simulator options: reltol=1e-5
  Files: definitions /home/admin/Documents/Erick_dev_git_copy/agriculture-SoC/analog/cadence/verif_comparator/tbcmp_stim.scs
  Analysis tran: stop=VAR("tstop") errpreset=moderate
  Output kick_inp = peakToPeak(clip(VT("/inp") (5.5 / VAR("fclk")) (6.5 / VAR("fclk"))))
  Output kick_inn = peakToPeak(clip(VT("/inn") (5.5 / VAR("fclk")) (6.5 / VAR("fclk"))))
  Output kick_diff = peakToPeak(clip((VT("/inp") - VT("/inn")) (5.5 / VAR("fclk")) (6.5 / VAR("fclk"))))
  Output resid_diff = (value((VT("/inp") - VT("/inn")) (6.5 / VAR("fclk"))) - value((VT("/inp") - VT("/inn")) (5.5 / VAR("fclk"))))
Test Power_energy: sar_adc/tb_comparator_parasitic/schematic, simulator spectre
  Models: /home/admin/Documents/PDKs/sky130_release_0.1.0/models/sky130.lib.spice[tt]
  Variables: ncyc = 16; vos = 0; pol = -1; tsu = 0.5n; vagg = 300m; nrep = 1; nsteps = 61; vstep = 1m; vstart = -30m; mode = 2; cload = 10f; ccdac = 9.3p; rs = 1; trim_b = 8; trim_a = 8; tf = 100p; tr = 100p; duty = 0.5; fclk = 1M; vd = 1m 10m 100m; vcm = 0.9; vcc = 1.8; tstop = (ncyc+1)/fclk
  Temperature: 27
  Simulator options: reltol=1e-5
  Files: definitions /home/admin/Documents/Erick_dev_git_copy/agriculture-SoC/analog/cadence/verif_comparator/tbcmp_stim.scs
  Analysis tran: stop=VAR("tstop") errpreset=moderate
  Output E_cycle = (integ(((- VAR("vcc")) * IT("/V0/PLUS")) ((4.5 + VAR("duty")) / VAR("fclk")) ((14.5 + VAR("duty")) / VAR("fclk"))) / 10)
  Output P_avg = ((integ(((- VAR("vcc")) * IT("/V0/PLUS")) ((4.5 + VAR("duty")) / VAR("fclk")) ((14.5 + VAR("duty")) / VAR("fclk"))) / 10) * VAR("fclk"))
  Output E_eval = integ(((- VAR("vcc")) * IT("/V0/PLUS")) (5.5 / VAR("fclk")) ((5.5 + VAR("duty")) / VAR("fclk")))
  Output E_reset = integ(((- VAR("vcc")) * IT("/V0/PLUS")) ((5.5 + VAR("duty")) / VAR("fclk")) (6.5 / VAR("fclk")))
Test History_dep: sar_adc/tb_comparator_parasitic/schematic, simulator spectre
  Models: /home/admin/Documents/PDKs/sky130_release_0.1.0/models/sky130.lib.spice[tt]
  Variables: ncyc = 324; vos = 0; pol = -1; tsu = 0.5n; vagg = 300m; nrep = 1; nsteps = 81; vstep = 0.25m; vstart = -10m; mode = 3; cload = 10f; ccdac = 9.3p; rs = 1; trim_b = 8; trim_a = 8; tf = 100p; tr = 100p; duty = 0.5; fclk = 1M; vd = 10m; vcm = 0.9; vcc = 1.8; tstop = (ncyc+1)/fclk
  Temperature: 27
  Simulator options: reltol=1e-5
  Files: definitions /home/admin/Documents/Erick_dev_git_copy/agriculture-SoC/analog/cadence/verif_comparator/tbcmp_stim.scs
  Analysis tran: stop=VAR("tstop") errpreset=moderate
  Output Vth_after_pos = tbcmp_hist(VT("/outp") VT("/outn") VAR("fclk") VAR("duty") VAR("tsu") VAR("vstart") VAR("vstep") VAR("nsteps") VAR("vcc") VAR("pol") 1)
  Output Vth_after_neg = tbcmp_hist(VT("/outp") VT("/outn") VAR("fclk") VAR("duty") VAR("tsu") VAR("vstart") VAR("vstep") VAR("nsteps") VAR("vcc") VAR("pol") -1)
  Output dVth_hist = tbcmp_hist(VT("/outp") VT("/outn") VAR("fclk") VAR("duty") VAR("tsu") VAR("vstart") VAR("vstep") VAR("nsteps") VAR("vcc") VAR("pol") 0)
Test Clk_freq: sar_adc/tb_comparator_parasitic/schematic, simulator spectre
  Models: /home/admin/Documents/PDKs/sky130_release_0.1.0/models/sky130.lib.spice[tt]
  Variables: ncyc = 8; vos = 0; pol = -1; tsu = 0.5n; vagg = 300m; nrep = 1; nsteps = 61; vstep = 1m; vstart = -30m; mode = 2; cload = 10f; ccdac = 9.3p; rs = 1; trim_b = 8; trim_a = 8; tf = 100p; tr = 100p; duty = 0.5; fclk = 1M 2M 5M 10M 20M 50M 100M; vd = 10m; vcm = 0.9; vcc = 1.8; tstop = (ncyc+1)/fclk
  Temperature: 27
  Simulator options: reltol=1e-5
  Files: definitions /home/admin/Documents/Erick_dev_git_copy/agriculture-SoC/analog/cadence/verif_comparator/tbcmp_stim.scs
  Analysis tran: stop=VAR("tstop") errpreset=moderate
  Output t_cq = delay(?wf1 VT("/clk") ?value1 (VAR("vcc") / 2) ?edge1 "rising" ?nth1 4 ?wf2 abs((VT("/outp") - VT("/outn"))) ?value2 (VAR("vcc") / 2) ?edge2 "rising" ?nth2 4)
  Output t_cq_frac = (delay(?wf1 VT("/clk") ?value1 (VAR("vcc") / 2) ?edge1 "rising" ?nth1 4 ?wf2 abs((VT("/outp") - VT("/outn"))) ?value2 (VAR("vcc") / 2) ?edge2 "rising" ?nth2 4) / ((VAR("duty") / VAR("fclk")) - VAR("tsu")))
  Output n_correct = tbcmp_count(VT("/outp") VT("/outn") VAR("fclk") VAR("duty") VAR("tsu") VAR("mode") VAR("vd") VAR("vstart") VAR("vstep") VAR("nrep") VAR("ncyc") VAR("vos") VAR("vcc") VAR("pol") "correct")
  Output n_unres = tbcmp_count(VT("/outp") VT("/outn") VAR("fclk") VAR("duty") VAR("tsu") VAR("mode") VAR("vd") VAR("vstart") VAR("vstep") VAR("nrep") VAR("ncyc") VAR("vos") VAR("vcc") VAR("pol") "unresolved")
  Output n_wrong = tbcmp_count(VT("/outp") VT("/outn") VAR("fclk") VAR("duty") VAR("tsu") VAR("mode") VAR("vd") VAR("vstart") VAR("vstep") VAR("nrep") VAR("ncyc") VAR("vos") VAR("vcc") VAR("pol") "wrong")
Test Clk_edge: sar_adc/tb_comparator_parasitic/schematic, simulator spectre
  Models: /home/admin/Documents/PDKs/sky130_release_0.1.0/models/sky130.lib.spice[tt]
  Variables: ncyc = 8; vos = 0; pol = -1; tsu = 0.5n; vagg = 300m; nrep = 1; nsteps = 61; vstep = 1m; vstart = -30m; mode = 2; cload = 10f; ccdac = 9.3p; rs = 1; trim_b = 8; trim_a = 8; tr = 50p 200p 1n 5n; duty = 0.5; fclk = 1M; vd = 10m; vcm = 0.9; vcc = 1.8; tf = tr; tstop = (ncyc+1)/fclk
  Temperature: 27
  Simulator options: reltol=1e-5
  Files: definitions /home/admin/Documents/Erick_dev_git_copy/agriculture-SoC/analog/cadence/verif_comparator/tbcmp_stim.scs
  Analysis tran: stop=VAR("tstop") errpreset=moderate
  Output t_cq = delay(?wf1 VT("/clk") ?value1 (VAR("vcc") / 2) ?edge1 "rising" ?nth1 4 ?wf2 abs((VT("/outp") - VT("/outn"))) ?value2 (VAR("vcc") / 2) ?edge2 "rising" ?nth2 4)
  Output t_cq_frac = (delay(?wf1 VT("/clk") ?value1 (VAR("vcc") / 2) ?edge1 "rising" ?nth1 4 ?wf2 abs((VT("/outp") - VT("/outn"))) ?value2 (VAR("vcc") / 2) ?edge2 "rising" ?nth2 4) / ((VAR("duty") / VAR("fclk")) - VAR("tsu")))
  Output n_correct = tbcmp_count(VT("/outp") VT("/outn") VAR("fclk") VAR("duty") VAR("tsu") VAR("mode") VAR("vd") VAR("vstart") VAR("vstep") VAR("nrep") VAR("ncyc") VAR("vos") VAR("vcc") VAR("pol") "correct")
  Output n_unres = tbcmp_count(VT("/outp") VT("/outn") VAR("fclk") VAR("duty") VAR("tsu") VAR("mode") VAR("vd") VAR("vstart") VAR("vstep") VAR("nrep") VAR("ncyc") VAR("vos") VAR("vcc") VAR("pol") "unresolved")
  Output n_wrong = tbcmp_count(VT("/outp") VT("/outn") VAR("fclk") VAR("duty") VAR("tsu") VAR("mode") VAR("vd") VAR("vstart") VAR("vstep") VAR("nrep") VAR("ncyc") VAR("vos") VAR("vcc") VAR("pol") "wrong")
Test Clk_duty: sar_adc/tb_comparator_parasitic/schematic, simulator spectre
  Models: /home/admin/Documents/PDKs/sky130_release_0.1.0/models/sky130.lib.spice[tt]
  Variables: ncyc = 8; vos = 0; pol = -1; tsu = 0.5n; vagg = 300m; nrep = 1; nsteps = 61; vstep = 1m; vstart = -30m; mode = 2; cload = 10f; ccdac = 9.3p; rs = 1; trim_b = 8; trim_a = 8; tf = 100p; tr = 100p; duty = 0.2 0.3 0.4 0.5 0.6 0.7 0.8; fclk = 1M; vd = 10m; vcm = 0.9; vcc = 1.8; tstop = (ncyc+1)/fclk
  Temperature: 27
  Simulator options: reltol=1e-5
  Files: definitions /home/admin/Documents/Erick_dev_git_copy/agriculture-SoC/analog/cadence/verif_comparator/tbcmp_stim.scs
  Analysis tran: stop=VAR("tstop") errpreset=moderate
  Output t_cq = delay(?wf1 VT("/clk") ?value1 (VAR("vcc") / 2) ?edge1 "rising" ?nth1 4 ?wf2 abs((VT("/outp") - VT("/outn"))) ?value2 (VAR("vcc") / 2) ?edge2 "rising" ?nth2 4)
  Output t_cq_frac = (delay(?wf1 VT("/clk") ?value1 (VAR("vcc") / 2) ?edge1 "rising" ?nth1 4 ?wf2 abs((VT("/outp") - VT("/outn"))) ?value2 (VAR("vcc") / 2) ?edge2 "rising" ?nth2 4) / ((VAR("duty") / VAR("fclk")) - VAR("tsu")))
  Output n_correct = tbcmp_count(VT("/outp") VT("/outn") VAR("fclk") VAR("duty") VAR("tsu") VAR("mode") VAR("vd") VAR("vstart") VAR("vstep") VAR("nrep") VAR("ncyc") VAR("vos") VAR("vcc") VAR("pol") "correct")
  Output n_unres = tbcmp_count(VT("/outp") VT("/outn") VAR("fclk") VAR("duty") VAR("tsu") VAR("mode") VAR("vd") VAR("vstart") VAR("vstep") VAR("nrep") VAR("ncyc") VAR("vos") VAR("vcc") VAR("pol") "unresolved")
  Output n_wrong = tbcmp_count(VT("/outp") VT("/outn") VAR("fclk") VAR("duty") VAR("tsu") VAR("mode") VAR("vd") VAR("vstart") VAR("vstep") VAR("nrep") VAR("ncyc") VAR("vos") VAR("vcc") VAR("pol") "wrong")
Test Clk_reset: sar_adc/tb_comparator_parasitic/schematic, simulator spectre
  Models: /home/admin/Documents/PDKs/sky130_release_0.1.0/models/sky130.lib.spice[tt]
  Variables: t_eval = 500n; t_rst = 1n 2n 5n 10n 50n 200n 500n; ncyc = 8; vos = 0; pol = -1; tsu = 0.5n; vagg = 300m; nrep = 1; nsteps = 61; vstep = 1m; vstart = -30m; mode = 2; cload = 10f; ccdac = 9.3p; rs = 1; trim_b = 8; trim_a = 8; tf = 100p; tr = 100p; vd = 10m; vcm = 0.9; vcc = 1.8; duty = t_eval/(t_eval+t_rst); fclk = 1/(t_eval+t_rst); tstop = (ncyc+1)/fclk
  Temperature: 27
  Simulator options: reltol=1e-5
  Files: definitions /home/admin/Documents/Erick_dev_git_copy/agriculture-SoC/analog/cadence/verif_comparator/tbcmp_stim.scs
  Analysis tran: stop=VAR("tstop") errpreset=moderate
  Output t_cq = delay(?wf1 VT("/clk") ?value1 (VAR("vcc") / 2) ?edge1 "rising" ?nth1 4 ?wf2 abs((VT("/outp") - VT("/outn"))) ?value2 (VAR("vcc") / 2) ?edge2 "rising" ?nth2 4)
  Output t_cq_frac = (delay(?wf1 VT("/clk") ?value1 (VAR("vcc") / 2) ?edge1 "rising" ?nth1 4 ?wf2 abs((VT("/outp") - VT("/outn"))) ?value2 (VAR("vcc") / 2) ?edge2 "rising" ?nth2 4) / ((VAR("duty") / VAR("fclk")) - VAR("tsu")))
  Output n_correct = tbcmp_count(VT("/outp") VT("/outn") VAR("fclk") VAR("duty") VAR("tsu") VAR("mode") VAR("vd") VAR("vstart") VAR("vstep") VAR("nrep") VAR("ncyc") VAR("vos") VAR("vcc") VAR("pol") "correct")
  Output n_unres = tbcmp_count(VT("/outp") VT("/outn") VAR("fclk") VAR("duty") VAR("tsu") VAR("mode") VAR("vd") VAR("vstart") VAR("vstep") VAR("nrep") VAR("ncyc") VAR("vos") VAR("vcc") VAR("pol") "unresolved")
  Output n_wrong = tbcmp_count(VT("/outp") VT("/outn") VAR("fclk") VAR("duty") VAR("tsu") VAR("mode") VAR("vd") VAR("vstart") VAR("vstep") VAR("nrep") VAR("ncyc") VAR("vos") VAR("vcc") VAR("pol") "wrong")
Test Output_compat: sar_adc/tb_comparator_parasitic/schematic, simulator spectre
  Models: /home/admin/Documents/PDKs/sky130_release_0.1.0/models/sky130.lib.spice[tt]
  Variables: ncyc = 8; vos = 0; pol = -1; tsu = 0.5n; vagg = 300m; nrep = 1; nsteps = 61; vstep = 1m; vstart = -30m; mode = 2; cload = 5f 10f 50f; ccdac = 9.3p; rs = 1; trim_b = 8; trim_a = 8; tf = 100p; tr = 100p; duty = 0.5; fclk = 1M; vd = 10m; vcm = 0.9; vcc = 1.8; tstop = (ncyc+1)/fclk
  Temperature: 27
  Simulator options: reltol=1e-5
  Files: definitions /home/admin/Documents/Erick_dev_git_copy/agriculture-SoC/analog/cadence/verif_comparator/tbcmp_stim.scs
  Analysis tran: stop=VAR("tstop") errpreset=moderate
  Output V_high = (max(value(VT("/outp") (((3.5 + VAR("duty")) / VAR("fclk")) - VAR("tsu"))) value(VT("/outn") (((3.5 + VAR("duty")) / VAR("fclk")) - VAR("tsu")))) / VAR("vcc"))
  Output V_low = (min(value(VT("/outp") (((3.5 + VAR("duty")) / VAR("fclk")) - VAR("tsu"))) value(VT("/outn") (((3.5 + VAR("duty")) / VAR("fclk")) - VAR("tsu")))) / VAR("vcc"))
  Output V_peak = (max(ymax(clip(VT("/outp") (2.5 / VAR("fclk")) (4.5 / VAR("fclk")))) ymax(clip(VT("/outn") (2.5 / VAR("fclk")) (4.5 / VAR("fclk"))))) / VAR("vcc"))
  Output V_undershoot = (min(ymin(clip(VT("/outp") (2.5 / VAR("fclk")) (4.5 / VAR("fclk")))) ymin(clip(VT("/outn") (2.5 / VAR("fclk")) (4.5 / VAR("fclk"))))) / VAR("vcc"))
  Output t_cq = delay(?wf1 VT("/clk") ?value1 (VAR("vcc") / 2) ?edge1 "rising" ?nth1 4 ?wf2 abs((VT("/outp") - VT("/outn"))) ?value2 (VAR("vcc") / 2) ?edge2 "rising" ?nth2 4)
  Output setup_margin = ((VAR("duty") / VAR("fclk")) - VAR("tsu") - delay(?wf1 VT("/clk") ?value1 (VAR("vcc") / 2) ?edge1 "rising" ?nth1 4 ?wf2 abs((VT("/outp") - VT("/outn"))) ?value2 (VAR("vcc") / 2) ?edge2 "rising" ?nth2 4))
  Output hold_t_after_clk = delay(?wf1 VT("/clk") ?value1 (VAR("vcc") / 2) ?edge1 "falling" ?nth1 3 ?wf2 abs((VT("/outp") - VT("/outn"))) ?value2 (0.1 * VAR("vcc")) ?edge2 "falling" ?nth2 3)
  Output n_unres = tbcmp_count(VT("/outp") VT("/outn") VAR("fclk") VAR("duty") VAR("tsu") VAR("mode") VAR("vd") VAR("vstart") VAR("vstep") VAR("nrep") VAR("ncyc") VAR("vos") VAR("vcc") VAR("pol") "unresolved")
Test PVT: sar_adc/tb_comparator_parasitic/schematic, simulator spectre
  Models: /home/admin/Documents/PDKs/sky130_release_0.1.0/models/sky130.lib.spice[tt]
  Variables: vos = 0; pol = -1; tsu = 0.5n; vagg = 300m; nrep = 1; nsteps = 61; vstep = 1m; vstart = -30m; mode = 1; cload = 10f; ccdac = 9.3p; rs = 1; trim_b = 8; trim_a = 8; tf = 100p; tr = 100p; duty = 0.5; fclk = 1M; vd = 10m; vcm = 0.9; vcc = 1.8; ncyc = nsteps*nrep; tstop = (ncyc+1)/fclk
  Temperature: 27
  Simulator options: reltol=1e-5
  Files: definitions /home/admin/Documents/Erick_dev_git_copy/agriculture-SoC/analog/cadence/verif_comparator/tbcmp_stim.scs
  Analysis tran: stop=VAR("tstop") errpreset=moderate
  Output Vos = tbcmp_vos(VT("/outp") VT("/outn") VAR("fclk") VAR("duty") VAR("tsu") VAR("vstart") VAR("vstep") VAR("nsteps") VAR("nrep") VAR("vcc") VAR("pol"))
  Output t_cq = delay(?wf1 VT("/clk") ?value1 (VAR("vcc") / 2) ?edge1 "rising" ?nth1 4 ?wf2 abs((VT("/outp") - VT("/outn"))) ?value2 (VAR("vcc") / 2) ?edge2 "rising" ?nth2 4)
  Output n_wrong = tbcmp_count(VT("/outp") VT("/outn") VAR("fclk") VAR("duty") VAR("tsu") VAR("mode") VAR("vd") VAR("vstart") VAR("vstep") VAR("nrep") VAR("ncyc") VAR("vos") VAR("vcc") VAR("pol") "wrong")
  Output n_unres = tbcmp_count(VT("/outp") VT("/outn") VAR("fclk") VAR("duty") VAR("tsu") VAR("mode") VAR("vd") VAR("vstart") VAR("vstep") VAR("nrep") VAR("ncyc") VAR("vos") VAR("vcc") VAR("pol") "unresolved")
  Output E_cycle = (integ(((- VAR("vcc")) * IT("/V0/PLUS")) ((4.5 + VAR("duty")) / VAR("fclk")) ((14.5 + VAR("duty")) / VAR("fclk"))) / 10)
Test MC_mismatch: sar_adc/tb_comparator_parasitic/schematic, simulator spectre
  Models: /home/admin/Documents/PDKs/sky130_release_0.1.0/models/sky130.lib.spice[tt]
  Variables: vos = 0; pol = -1; tsu = 0.5n; vagg = 300m; nrep = 1; nsteps = 121; vstep = 1m; vstart = -60m; mode = 1; cload = 10f; ccdac = 9.3p; rs = 1; trim_b = 8; trim_a = 8; tf = 100p; tr = 100p; duty = 0.5; fclk = 1M; vd = 10m; vcm = 0.9; vcc = 1.8; ncyc = nsteps*nrep; tstop = (ncyc+1)/fclk
  Temperature: 27
  Simulator options: reltol=1e-5
  Files: definitions /home/admin/Documents/Erick_dev_git_copy/agriculture-SoC/analog/cadence/verif_comparator/tbcmp_stim.scs /home/admin/Documents/Erick_dev_git_copy/agriculture-SoC/analog/cadence/verif_comparator/tbcmp_mc.scs
  Analysis tran: stop=VAR("tstop") errpreset=moderate
  Output Vos = tbcmp_vos(VT("/outp") VT("/outn") VAR("fclk") VAR("duty") VAR("tsu") VAR("vstart") VAR("vstep") VAR("nsteps") VAR("nrep") VAR("vcc") VAR("pol"))
  Output t_cq = delay(?wf1 VT("/clk") ?value1 (VAR("vcc") / 2) ?edge1 "rising" ?nth1 4 ?wf2 abs((VT("/outp") - VT("/outn"))) ?value2 (VAR("vcc") / 2) ?edge2 "rising" ?nth2 4)
  Output E_cycle = (integ(((- VAR("vcc")) * IT("/V0/PLUS")) ((4.5 + VAR("duty")) / VAR("fclk")) ((14.5 + VAR("duty")) / VAR("fclk"))) / 10)
Test Trim_a: sar_adc/tb_comparator_parasitic/schematic, simulator spectre
  Models: /home/admin/Documents/PDKs/sky130_release_0.1.0/models/sky130.lib.spice[tt]
  Variables: vos = 0; pol = -1; tsu = 0.5n; vagg = 300m; nrep = 1; nsteps = 61; vstep = 1m; vstart = -30m; mode = 1; cload = 10f; ccdac = 9.3p; rs = 1; trim_b = 8; trim_a = 0:1:31; tf = 100p; tr = 100p; duty = 0.5; fclk = 1M; vd = 10m; vcm = 0.9; vcc = 1.8; ncyc = nsteps*nrep; tstop = (ncyc+1)/fclk
  Temperature: 27
  Simulator options: reltol=1e-5
  Files: definitions /home/admin/Documents/Erick_dev_git_copy/agriculture-SoC/analog/cadence/verif_comparator/tbcmp_stim.scs
  Analysis tran: stop=VAR("tstop") errpreset=moderate
  Output Vos = tbcmp_vos(VT("/outp") VT("/outn") VAR("fclk") VAR("duty") VAR("tsu") VAR("vstart") VAR("vstep") VAR("nsteps") VAR("nrep") VAR("vcc") VAR("pol"))
  Output t_cq = delay(?wf1 VT("/clk") ?value1 (VAR("vcc") / 2) ?edge1 "rising" ?nth1 4 ?wf2 abs((VT("/outp") - VT("/outn"))) ?value2 (VAR("vcc") / 2) ?edge2 "rising" ?nth2 4)
  Output E_cycle = (integ(((- VAR("vcc")) * IT("/V0/PLUS")) ((4.5 + VAR("duty")) / VAR("fclk")) ((14.5 + VAR("duty")) / VAR("fclk"))) / 10)
Test Trim_b: sar_adc/tb_comparator_parasitic/schematic, simulator spectre
  Models: /home/admin/Documents/PDKs/sky130_release_0.1.0/models/sky130.lib.spice[tt]
  Variables: vos = 0; pol = -1; tsu = 0.5n; vagg = 300m; nrep = 1; nsteps = 61; vstep = 1m; vstart = -30m; mode = 1; cload = 10f; ccdac = 9.3p; rs = 1; trim_b = 0:1:31; trim_a = 8; tf = 100p; tr = 100p; duty = 0.5; fclk = 1M; vd = 10m; vcm = 0.9; vcc = 1.8; ncyc = nsteps*nrep; tstop = (ncyc+1)/fclk
  Temperature: 27
  Simulator options: reltol=1e-5
  Files: definitions /home/admin/Documents/Erick_dev_git_copy/agriculture-SoC/analog/cadence/verif_comparator/tbcmp_stim.scs
  Analysis tran: stop=VAR("tstop") errpreset=moderate
  Output Vos = tbcmp_vos(VT("/outp") VT("/outn") VAR("fclk") VAR("duty") VAR("tsu") VAR("vstart") VAR("vstep") VAR("nsteps") VAR("nrep") VAR("vcc") VAR("pol"))
  Output t_cq = delay(?wf1 VT("/clk") ?value1 (VAR("vcc") / 2) ?edge1 "rising" ?nth1 4 ?wf2 abs((VT("/outp") - VT("/outn"))) ?value2 (VAR("vcc") / 2) ?edge2 "rising" ?nth2 4)
  Output E_cycle = (integ(((- VAR("vcc")) * IT("/V0/PLUS")) ((4.5 + VAR("duty")) / VAR("fclk")) ((14.5 + VAR("duty")) / VAR("fclk"))) / 10)
Test PEX_Basic_op: sar_adc/tb_comparator_parasitic/config_pex, simulator spectre
  Models: /home/admin/Documents/PDKs/sky130_release_0.1.0/models/sky130.lib.spice[tt]
  Variables: ncyc = 8; vos = 0; pol = 1; tsu = 0.5n; vagg = 300m; nrep = 1; nsteps = 61; vstep = 1m; vstart = -30m; mode = 2; cload = 10f; ccdac = 9.3p; rs = 1; trim_b = 8; trim_a = 8; tf = 100p; tr = 100p; duty = 0.5; fclk = 1M; vd = 5m 20m 100m; vcm = 0.9; vcc = 1.8; tstop = (ncyc+1)/fclk
  Temperature: 27
  Simulator options: reltol=1e-5
  Files: definitions /home/admin/Documents/Erick_dev_git_copy/agriculture-SoC/analog/cadence/verif_comparator/tbcmp_stim.scs
  Analysis tran: stop=VAR("tstop") errpreset=moderate
  Output dec_pos = tbcmpDec(VT("/outp") VT("/outn") (((2.5 + VAR("duty")) / VAR("fclk")) - VAR("tsu")) VAR("vcc") VAR("pol"))
  Output dec_neg = tbcmpDec(VT("/outp") VT("/outn") (((3.5 + VAR("duty")) / VAR("fclk")) - VAR("tsu")) VAR("vcc") VAR("pol"))
  Output n_correct = tbcmp_count(VT("/outp") VT("/outn") VAR("fclk") VAR("duty") VAR("tsu") VAR("mode") VAR("vd") VAR("vstart") VAR("vstep") VAR("nrep") VAR("ncyc") VAR("vos") VAR("vcc") VAR("pol") "correct")
  Output n_wrong = tbcmp_count(VT("/outp") VT("/outn") VAR("fclk") VAR("duty") VAR("tsu") VAR("mode") VAR("vd") VAR("vstart") VAR("vstep") VAR("nrep") VAR("ncyc") VAR("vos") VAR("vcc") VAR("pol") "wrong")
  Output n_unres = tbcmp_count(VT("/outp") VT("/outn") VAR("fclk") VAR("duty") VAR("tsu") VAR("mode") VAR("vd") VAR("vstart") VAR("vstep") VAR("nrep") VAR("ncyc") VAR("vos") VAR("vcc") VAR("pol") "unresolved")
Test PEX_Off_set: sar_adc/tb_comparator_parasitic/config_pex, simulator spectre
  Models: /home/admin/Documents/PDKs/sky130_release_0.1.0/models/sky130.lib.spice[tt]
  Variables: vos = 0; pol = -1; tsu = 0.5n; vagg = 300m; nrep = 1; nsteps = 241; vstep = 0.25m; vstart = -30m; mode = 1; cload = 10f; ccdac = 9.3p; rs = 1; trim_b = 8; trim_a = 8; tf = 100p; tr = 100p; duty = 0.5; fclk = 1M; vd = 10m; vcm = 0.9; vcc = 1.8; ncyc = nsteps*nrep; tstop = (ncyc+1)/fclk
  Temperature: 27
  Simulator options: reltol=1e-5
  Files: definitions /home/admin/Documents/Erick_dev_git_copy/agriculture-SoC/analog/cadence/verif_comparator/tbcmp_stim.scs
  Analysis tran: stop=VAR("tstop") errpreset=moderate
  Output Vos = tbcmp_vos(VT("/outp") VT("/outn") VAR("fclk") VAR("duty") VAR("tsu") VAR("vstart") VAR("vstep") VAR("nsteps") VAR("nrep") VAR("vcc") VAR("pol"))
Test PEX_Decision_delay: sar_adc/tb_comparator_parasitic/config_pex, simulator spectre
  Models: /home/admin/Documents/PDKs/sky130_release_0.1.0/models/sky130.lib.spice[tt]
  Variables: ncyc = 6; vos = 0; pol = -1; tsu = 0.5n; vagg = 300m; nrep = 1; nsteps = 61; vstep = 1m; vstart = -30m; mode = 0; cload = 10f; ccdac = 9.3p; rs = 1; trim_b = 8; trim_a = 8; tf = 100p; tr = 100p; duty = 0.5; fclk = 1M; vd = -100m -10m -1m 1m 3m 10m 30m 100m 300m; vcm = 0.9; vcc = 1.8; tstop = (ncyc+1)/fclk
  Temperature: 27
  Simulator options: reltol=1e-5
  Files: definitions /home/admin/Documents/Erick_dev_git_copy/agriculture-SoC/analog/cadence/verif_comparator/tbcmp_stim.scs
  Analysis tran: stop=VAR("tstop") errpreset=moderate
  Output t_cq = delay(?wf1 VT("/clk") ?value1 (VAR("vcc") / 2) ?edge1 "rising" ?nth1 4 ?wf2 abs((VT("/outp") - VT("/outn"))) ?value2 (VAR("vcc") / 2) ?edge2 "rising" ?nth2 4)
  Output t_cq_frac = (delay(?wf1 VT("/clk") ?value1 (VAR("vcc") / 2) ?edge1 "rising" ?nth1 4 ?wf2 abs((VT("/outp") - VT("/outn"))) ?value2 (VAR("vcc") / 2) ?edge2 "rising" ?nth2 4) / ((VAR("duty") / VAR("fclk")) - VAR("tsu")))
Test PEX_Kickback: sar_adc/tb_comparator_parasitic/config_pex, simulator spectre
  Models: /home/admin/Documents/PDKs/sky130_release_0.1.0/models/sky130.lib.spice[tt]
  Variables: ncyc = 8; vos = 0; pol = -1; tsu = 0.5n; vagg = 300m; nrep = 1; nsteps = 61; vstep = 1m; vstart = -30m; mode = 0; cload = 10f; ccdac = 9.3p 1p 100f; rs = 1G; trim_b = 8; trim_a = 8; tf = 100p; tr = 100p; duty = 0.5; fclk = 1M; vd = 1m 100m; vcm = 0.9; vcc = 1.8; tstop = (ncyc+1)/fclk
  Temperature: 27
  Simulator options: reltol=1e-5
  Files: definitions /home/admin/Documents/Erick_dev_git_copy/agriculture-SoC/analog/cadence/verif_comparator/tbcmp_stim.scs
  Analysis tran: stop=VAR("tstop") errpreset=moderate
  Output kick_inp = peakToPeak(clip(VT("/inp") (5.5 / VAR("fclk")) (6.5 / VAR("fclk"))))
  Output kick_inn = peakToPeak(clip(VT("/inn") (5.5 / VAR("fclk")) (6.5 / VAR("fclk"))))
  Output kick_diff = peakToPeak(clip((VT("/inp") - VT("/inn")) (5.5 / VAR("fclk")) (6.5 / VAR("fclk"))))
  Output resid_diff = (value((VT("/inp") - VT("/inn")) (6.5 / VAR("fclk"))) - value((VT("/inp") - VT("/inn")) (5.5 / VAR("fclk"))))
Test PEX_Power_energy: sar_adc/tb_comparator_parasitic/config_pex, simulator spectre
  Models: /home/admin/Documents/PDKs/sky130_release_0.1.0/models/sky130.lib.spice[tt]
  Variables: ncyc = 16; vos = 0; pol = -1; tsu = 0.5n; vagg = 300m; nrep = 1; nsteps = 61; vstep = 1m; vstart = -30m; mode = 2; cload = 10f; ccdac = 9.3p; rs = 1; trim_b = 8; trim_a = 8; tf = 100p; tr = 100p; duty = 0.5; fclk = 1M; vd = 1m 10m 100m; vcm = 0.9; vcc = 1.8; tstop = (ncyc+1)/fclk
  Temperature: 27
  Simulator options: reltol=1e-5
  Files: definitions /home/admin/Documents/Erick_dev_git_copy/agriculture-SoC/analog/cadence/verif_comparator/tbcmp_stim.scs
  Analysis tran: stop=VAR("tstop") errpreset=moderate
  Output E_cycle = (integ(((- VAR("vcc")) * IT("/V0/PLUS")) ((4.5 + VAR("duty")) / VAR("fclk")) ((14.5 + VAR("duty")) / VAR("fclk"))) / 10)
  Output P_avg = ((integ(((- VAR("vcc")) * IT("/V0/PLUS")) ((4.5 + VAR("duty")) / VAR("fclk")) ((14.5 + VAR("duty")) / VAR("fclk"))) / 10) * VAR("fclk"))
  Output E_eval = integ(((- VAR("vcc")) * IT("/V0/PLUS")) (5.5 / VAR("fclk")) ((5.5 + VAR("duty")) / VAR("fclk")))
  Output E_reset = integ(((- VAR("vcc")) * IT("/V0/PLUS")) ((5.5 + VAR("duty")) / VAR("fclk")) (6.5 / VAR("fclk")))
Test Off_set: sar_adc/tb_comparator_parasitic/schematic, simulator spectre
  Models: /home/admin/Documents/PDKs/sky130_release_0.1.0/models/sky130.lib.spice[tt]
  Variables: vos = 0; pol = -1; tsu = 0.5n; vagg = 300m; nrep = 1; nsteps = 241; vstep = 0.25m; vstart = -30m; mode = 1; cload = 10f; ccdac = 9.3p; rs = 1; trim_b = 8; trim_a = 8; tf = 100p; tr = 100p; duty = 0.5; fclk = 1M; vd = 10m; vcm = 0.9; vcc = 1.8; ncyc = nsteps*nrep; tstop = (ncyc+1)/fclk
  Temperature: 27
  Simulator options: reltol=1e-5
  Files: definitions /home/admin/Documents/Erick_dev_git_copy/agriculture-SoC/analog/cadence/verif_comparator/tbcmp_stim.scs
  Analysis tran: stop=VAR("tstop") errpreset=moderate
  Output Vos = tbcmp_vos(VT("/outp") VT("/outn") VAR("fclk") VAR("duty") VAR("tsu") VAR("vstart") VAR("vstep") VAR("nsteps") VAR("nrep") VAR("vcc") VAR("pol"))
Test Input_ref_noise: sar_adc/tb_comparator_parasitic/schematic, simulator spectre
  Models: /home/admin/Documents/PDKs/sky130_release_0.1.0/models/sky130.lib.spice[tt]
  Variables: vos = 0; pol = -1; tsu = 0.5n; vagg = 300m; nrep = 20; nsteps = 25; vstep = 0.25m; vstart = -3m; mode = 1; cload = 10f; ccdac = 9.3p; rs = 1; trim_b = 8; trim_a = 8; tf = 100p; tr = 100p; duty = 0.5; fclk = 5M; vd = 10m; vcm = 0.9; vcc = 1.8; ncyc = nsteps*nrep; tstop = (ncyc+1)/fclk
  Temperature: 27
  Simulator options: reltol=1e-5
  Files: definitions /home/admin/Documents/Erick_dev_git_copy/agriculture-SoC/analog/cadence/verif_comparator/tbcmp_stim.scs
  Analysis tran: stop=VAR("tstop") errpreset=moderate noisefmax=5G noisefmin=50k
  Output Vos_noisy = tbcmp_vos(VT("/outp") VT("/outn") VAR("fclk") VAR("duty") VAR("tsu") VAR("vstart") VAR("vstep") VAR("nsteps") VAR("nrep") VAR("vcc") VAR("pol"))
  Output sigma_n = tbcmp_sigma(VT("/outp") VT("/outn") VAR("fclk") VAR("duty") VAR("tsu") VAR("vstart") VAR("vstep") VAR("nsteps") VAR("nrep") VAR("vcc") VAR("pol"))
Test Decision_delay: sar_adc/tb_comparator_parasitic/schematic, simulator spectre
  Models: /home/admin/Documents/PDKs/sky130_release_0.1.0/models/sky130.lib.spice[tt]
  Variables: ncyc = 6; vos = 0; pol = -1; tsu = 0.5n; vagg = 300m; nrep = 1; nsteps = 61; vstep = 1m; vstart = -30m; mode = 0; cload = 10f; ccdac = 9.3p; rs = 1; trim_b = 8; trim_a = 8; tf = 100p; tr = 100p; duty = 0.5; fclk = 1M; vd = -100m -10m -1m 1m 3m 10m 30m 100m 300m; vcm = 0.9; vcc = 1.8; tstop = (ncyc+1)/fclk
  Temperature: 27
  Simulator options: reltol=1e-5
  Files: definitions /home/admin/Documents/Erick_dev_git_copy/agriculture-SoC/analog/cadence/verif_comparator/tbcmp_stim.scs
  Analysis tran: stop=VAR("tstop") errpreset=moderate
  Output t_cq = delay(?wf1 VT("/clk") ?value1 (VAR("vcc") / 2) ?edge1 "rising" ?nth1 4 ?wf2 abs((VT("/outp") - VT("/outn"))) ?value2 (VAR("vcc") / 2) ?edge2 "rising" ?nth2 4)
  Output t_cq_frac = (delay(?wf1 VT("/clk") ?value1 (VAR("vcc") / 2) ?edge1 "rising" ?nth1 4 ?wf2 abs((VT("/outp") - VT("/outn"))) ?value2 (VAR("vcc") / 2) ?edge2 "rising" ?nth2 4) / ((VAR("duty") / VAR("fclk")) - VAR("tsu")))
Test Metastability: sar_adc/tb_comparator_parasitic/schematic, simulator spectre
  Models: /home/admin/Documents/PDKs/sky130_release_0.1.0/models/sky130.lib.spice[tt]
  Variables: vos = -125u; pol = -1; tsu = 0.5n; vagg = 300m; nrep = 1; nsteps = 101; vstep = 1u; mode = 1; cload = 10f; ccdac = 9.3p; rs = 1; trim_b = 8; trim_a = 8; tf = 100p; tr = 100p; duty = 0.5; fclk = 1M 5M 20M; vd = 10m; vcm = 0.9; vcc = 1.8; ncyc = nsteps*nrep; vstart = vos-50u; tstop = (ncyc+1)/fclk
  Temperature: 27
  Simulator options: reltol=1e-5
  Files: definitions /home/admin/Documents/Erick_dev_git_copy/agriculture-SoC/analog/cadence/verif_comparator/tbcmp_stim.scs
  Analysis tran: stop=VAR("tstop") errpreset=moderate
  Output n_wrong = tbcmp_count(VT("/outp") VT("/outn") VAR("fclk") VAR("duty") VAR("tsu") VAR("mode") VAR("vd") VAR("vstart") VAR("vstep") VAR("nrep") VAR("ncyc") VAR("vos") VAR("vcc") VAR("pol") "wrong")
  Output n_unres = tbcmp_count(VT("/outp") VT("/outn") VAR("fclk") VAR("duty") VAR("tsu") VAR("mode") VAR("vd") VAR("vstart") VAR("vstep") VAR("nrep") VAR("ncyc") VAR("vos") VAR("vcc") VAR("pol") "unresolved")
  Output n_correct = tbcmp_count(VT("/outp") VT("/outn") VAR("fclk") VAR("duty") VAR("tsu") VAR("mode") VAR("vd") VAR("vstart") VAR("vstep") VAR("nrep") VAR("ncyc") VAR("vos") VAR("vcc") VAR("pol") "correct")
  Output t_cq_worst = delay(?wf1 VT("/clk") ?value1 (VAR("vcc") / 2) ?edge1 "rising" ?nth1 51 ?wf2 abs((VT("/outp") - VT("/outn"))) ?value2 (VAR("vcc") / 2) ?edge2 "rising" ?nth2 51)
Test Basic_op: sar_adc/tb_comparator_parasitic/schematic, simulator spectre
  Models: /home/admin/Documents/PDKs/sky130_release_0.1.0/models/sky130.lib.spice[tt]
  Variables: ncyc = 8; vos = 0; pol = 1; tsu = 0.5n; vagg = 300m; nrep = 1; nsteps = 61; vstep = 1m; vstart = -30m; mode = 2; cload = 10f; ccdac = 9.3p; rs = 1; trim_b = 8; trim_a = 8; tf = 100p; tr = 100p; duty = 0.5; fclk = 1M; vd = 5m 20m 100m; vcm = 0.9; vcc = 1.8; tstop = (ncyc+1)/fclk
  Temperature: 27
  Simulator options: reltol=1e-5
  Files: definitions /home/admin/Documents/Erick_dev_git_copy/agriculture-SoC/analog/cadence/verif_comparator/tbcmp_stim.scs
  Analysis tran: stop=VAR("tstop") errpreset=moderate
  Output dec_pos = (tbcmpDec VT("/outp") VT("/outn") (((2.5 + VAR("duty")) / VAR("fclk")) - VAR("tsu")) VAR("vcc") VAR("pol"))
  Output dec_neg = (tbcmpDec VT("/outp") VT("/outn") (((3.5 + VAR("duty")) / VAR("fclk")) - VAR("tsu")) VAR("vcc") VAR("pol"))
  Output n_correct = (tbcmp_count VT("/outp") VT("/outn") VAR("fclk") VAR("duty") VAR("tsu") VAR("mode") VAR("vd") VAR("vstart") VAR("vstep") VAR("nrep") VAR("ncyc") VAR("vos") VAR("vcc") VAR("pol") "correct")
  Output n_wrong = (tbcmp_count VT("/outp") VT("/outn") VAR("fclk") VAR("duty") VAR("tsu") VAR("mode") VAR("vd") VAR("vstart") VAR("vstep") VAR("nrep") VAR("ncyc") VAR("vos") VAR("vcc") VAR("pol") "wrong")
  Output n_unres = (tbcmp_count VT("/outp") VT("/outn") VAR("fclk") VAR("duty") VAR("tsu") VAR("mode") VAR("vd") VAR("vstart") VAR("vstep") VAR("nrep") VAR("ncyc") VAR("vos") VAR("vcc") VAR("pol") "unresolved")
Run mode: Single Run, Sweeps and Corners
Corners:
  model folders: /home/admin/Documents/PDKs/sky130_release_0.1.0/models
  tt_v1p62_tm40: temperature=-40; vcc=1.62; sky130.lib.spice[tt]; not for Basic_op, Clk_duty, Clk_edge, Clk_freq, Clk_reset, Common_mode, Decision_delay, History_dep, Input_ref_noise, Kickback, MC_mismatch, Metastability, Off_set, Output_compat, PEX_Basic_op, PEX_Decision_delay, PEX_Kickback, PEX_Off_set, PEX_Power_energy, Power_energy, Reset_op, Trim_a, Trim_b
  tt_v1p62_t27: temperature=27; vcc=1.62; sky130.lib.spice[tt]; not for Basic_op, Clk_duty, Clk_edge, Clk_freq, Clk_reset, Common_mode, Decision_delay, History_dep, Input_ref_noise, Kickback, MC_mismatch, Metastability, Off_set, Output_compat, PEX_Basic_op, PEX_Decision_delay, PEX_Kickback, PEX_Off_set, PEX_Power_energy, Power_energy, Reset_op, Trim_a, Trim_b
  tt_v1p62_t125: temperature=125; vcc=1.62; sky130.lib.spice[tt]; not for Basic_op, Clk_duty, Clk_edge, Clk_freq, Clk_reset, Common_mode, Decision_delay, History_dep, Input_ref_noise, Kickback, MC_mismatch, Metastability, Off_set, Output_compat, PEX_Basic_op, PEX_Decision_delay, PEX_Kickback, PEX_Off_set, PEX_Power_energy, Power_energy, Reset_op, Trim_a, Trim_b
  tt_v1p8_tm40: temperature=-40; vcc=1.8; sky130.lib.spice[tt]; not for Basic_op, Clk_duty, Clk_edge, Clk_freq, Clk_reset, Common_mode, Decision_delay, History_dep, Input_ref_noise, Kickback, MC_mismatch, Metastability, Off_set, Output_compat, PEX_Basic_op, PEX_Decision_delay, PEX_Kickback, PEX_Off_set, PEX_Power_energy, Power_energy, Reset_op, Trim_a, Trim_b
  tt_v1p8_t27: temperature=27; vcc=1.8; sky130.lib.spice[tt]; not for Basic_op, Clk_duty, Clk_edge, Clk_freq, Clk_reset, Common_mode, Decision_delay, History_dep, Input_ref_noise, Kickback, MC_mismatch, Metastability, Off_set, Output_compat, PEX_Basic_op, PEX_Decision_delay, PEX_Kickback, PEX_Off_set, PEX_Power_energy, Power_energy, Reset_op, Trim_a, Trim_b
  tt_v1p8_t125: temperature=125; vcc=1.8; sky130.lib.spice[tt]; not for Basic_op, Clk_duty, Clk_edge, Clk_freq, Clk_reset, Common_mode, Decision_delay, History_dep, Input_ref_noise, Kickback, MC_mismatch, Metastability, Off_set, Output_compat, PEX_Basic_op, PEX_Decision_delay, PEX_Kickback, PEX_Off_set, PEX_Power_energy, Power_energy, Reset_op, Trim_a, Trim_b
  tt_v1p98_tm40: temperature=-40; vcc=1.98; sky130.lib.spice[tt]; not for Basic_op, Clk_duty, Clk_edge, Clk_freq, Clk_reset, Common_mode, Decision_delay, History_dep, Input_ref_noise, Kickback, MC_mismatch, Metastability, Off_set, Output_compat, PEX_Basic_op, PEX_Decision_delay, PEX_Kickback, PEX_Off_set, PEX_Power_energy, Power_energy, Reset_op, Trim_a, Trim_b
  tt_v1p98_t27: temperature=27; vcc=1.98; sky130.lib.spice[tt]; not for Basic_op, Clk_duty, Clk_edge, Clk_freq, Clk_reset, Common_mode, Decision_delay, History_dep, Input_ref_noise, Kickback, MC_mismatch, Metastability, Off_set, Output_compat, PEX_Basic_op, PEX_Decision_delay, PEX_Kickback, PEX_Off_set, PEX_Power_energy, Power_energy, Reset_op, Trim_a, Trim_b
  tt_v1p98_t125: temperature=125; vcc=1.98; sky130.lib.spice[tt]; not for Basic_op, Clk_duty, Clk_edge, Clk_freq, Clk_reset, Common_mode, Decision_delay, History_dep, Input_ref_noise, Kickback, MC_mismatch, Metastability, Off_set, Output_compat, PEX_Basic_op, PEX_Decision_delay, PEX_Kickback, PEX_Off_set, PEX_Power_energy, Power_energy, Reset_op, Trim_a, Trim_b
  ff_v1p62_tm40: temperature=-40; vcc=1.62; sky130.lib.spice[ff]; not for Basic_op, Clk_duty, Clk_edge, Clk_freq, Clk_reset, Common_mode, Decision_delay, History_dep, Input_ref_noise, Kickback, MC_mismatch, Metastability, Off_set, Output_compat, PEX_Basic_op, PEX_Decision_delay, PEX_Kickback, PEX_Off_set, PEX_Power_energy, Power_energy, Reset_op, Trim_a, Trim_b
  ff_v1p62_t27: temperature=27; vcc=1.62; sky130.lib.spice[ff]; not for Basic_op, Clk_duty, Clk_edge, Clk_freq, Clk_reset, Common_mode, Decision_delay, History_dep, Input_ref_noise, Kickback, MC_mismatch, Metastability, Off_set, Output_compat, PEX_Basic_op, PEX_Decision_delay, PEX_Kickback, PEX_Off_set, PEX_Power_energy, Power_energy, Reset_op, Trim_a, Trim_b
  ff_v1p62_t125: temperature=125; vcc=1.62; sky130.lib.spice[ff]; not for Basic_op, Clk_duty, Clk_edge, Clk_freq, Clk_reset, Common_mode, Decision_delay, History_dep, Input_ref_noise, Kickback, MC_mismatch, Metastability, Off_set, Output_compat, PEX_Basic_op, PEX_Decision_delay, PEX_Kickback, PEX_Off_set, PEX_Power_energy, Power_energy, Reset_op, Trim_a, Trim_b
  ff_v1p8_tm40: temperature=-40; vcc=1.8; sky130.lib.spice[ff]; not for Basic_op, Clk_duty, Clk_edge, Clk_freq, Clk_reset, Common_mode, Decision_delay, History_dep, Input_ref_noise, Kickback, MC_mismatch, Metastability, Off_set, Output_compat, PEX_Basic_op, PEX_Decision_delay, PEX_Kickback, PEX_Off_set, PEX_Power_energy, Power_energy, Reset_op, Trim_a, Trim_b
  ff_v1p8_t27: temperature=27; vcc=1.8; sky130.lib.spice[ff]; not for Basic_op, Clk_duty, Clk_edge, Clk_freq, Clk_reset, Common_mode, Decision_delay, History_dep, Input_ref_noise, Kickback, MC_mismatch, Metastability, Off_set, Output_compat, PEX_Basic_op, PEX_Decision_delay, PEX_Kickback, PEX_Off_set, PEX_Power_energy, Power_energy, Reset_op, Trim_a, Trim_b
  ff_v1p8_t125: temperature=125; vcc=1.8; sky130.lib.spice[ff]; not for Basic_op, Clk_duty, Clk_edge, Clk_freq, Clk_reset, Common_mode, Decision_delay, History_dep, Input_ref_noise, Kickback, MC_mismatch, Metastability, Off_set, Output_compat, PEX_Basic_op, PEX_Decision_delay, PEX_Kickback, PEX_Off_set, PEX_Power_energy, Power_energy, Reset_op, Trim_a, Trim_b
  ff_v1p98_tm40: temperature=-40; vcc=1.98; sky130.lib.spice[ff]; not for Basic_op, Clk_duty, Clk_edge, Clk_freq, Clk_reset, Common_mode, Decision_delay, History_dep, Input_ref_noise, Kickback, MC_mismatch, Metastability, Off_set, Output_compat, PEX_Basic_op, PEX_Decision_delay, PEX_Kickback, PEX_Off_set, PEX_Power_energy, Power_energy, Reset_op, Trim_a, Trim_b
  ff_v1p98_t27: temperature=27; vcc=1.98; sky130.lib.spice[ff]; not for Basic_op, Clk_duty, Clk_edge, Clk_freq, Clk_reset, Common_mode, Decision_delay, History_dep, Input_ref_noise, Kickback, MC_mismatch, Metastability, Off_set, Output_compat, PEX_Basic_op, PEX_Decision_delay, PEX_Kickback, PEX_Off_set, PEX_Power_energy, Power_energy, Reset_op, Trim_a, Trim_b
  ff_v1p98_t125: temperature=125; vcc=1.98; sky130.lib.spice[ff]; not for Basic_op, Clk_duty, Clk_edge, Clk_freq, Clk_reset, Common_mode, Decision_delay, History_dep, Input_ref_noise, Kickback, MC_mismatch, Metastability, Off_set, Output_compat, PEX_Basic_op, PEX_Decision_delay, PEX_Kickback, PEX_Off_set, PEX_Power_energy, Power_energy, Reset_op, Trim_a, Trim_b
  ss_v1p62_tm40: temperature=-40; vcc=1.62; sky130.lib.spice[ss]; not for Basic_op, Clk_duty, Clk_edge, Clk_freq, Clk_reset, Common_mode, Decision_delay, History_dep, Input_ref_noise, Kickback, MC_mismatch, Metastability, Off_set, Output_compat, PEX_Basic_op, PEX_Decision_delay, PEX_Kickback, PEX_Off_set, PEX_Power_energy, Power_energy, Reset_op, Trim_a, Trim_b
  ss_v1p62_t27: temperature=27; vcc=1.62; sky130.lib.spice[ss]; not for Basic_op, Clk_duty, Clk_edge, Clk_freq, Clk_reset, Common_mode, Decision_delay, History_dep, Input_ref_noise, Kickback, MC_mismatch, Metastability, Off_set, Output_compat, PEX_Basic_op, PEX_Decision_delay, PEX_Kickback, PEX_Off_set, PEX_Power_energy, Power_energy, Reset_op, Trim_a, Trim_b
  ss_v1p62_t125: temperature=125; vcc=1.62; sky130.lib.spice[ss]; not for Basic_op, Clk_duty, Clk_edge, Clk_freq, Clk_reset, Common_mode, Decision_delay, History_dep, Input_ref_noise, Kickback, MC_mismatch, Metastability, Off_set, Output_compat, PEX_Basic_op, PEX_Decision_delay, PEX_Kickback, PEX_Off_set, PEX_Power_energy, Power_energy, Reset_op, Trim_a, Trim_b
  ss_v1p8_tm40: temperature=-40; vcc=1.8; sky130.lib.spice[ss]; not for Basic_op, Clk_duty, Clk_edge, Clk_freq, Clk_reset, Common_mode, Decision_delay, History_dep, Input_ref_noise, Kickback, MC_mismatch, Metastability, Off_set, Output_compat, PEX_Basic_op, PEX_Decision_delay, PEX_Kickback, PEX_Off_set, PEX_Power_energy, Power_energy, Reset_op, Trim_a, Trim_b
  ss_v1p8_t27: temperature=27; vcc=1.8; sky130.lib.spice[ss]; not for Basic_op, Clk_duty, Clk_edge, Clk_freq, Clk_reset, Common_mode, Decision_delay, History_dep, Input_ref_noise, Kickback, MC_mismatch, Metastability, Off_set, Output_compat, PEX_Basic_op, PEX_Decision_delay, PEX_Kickback, PEX_Off_set, PEX_Power_energy, Power_energy, Reset_op, Trim_a, Trim_b
  ss_v1p8_t125: temperature=125; vcc=1.8; sky130.lib.spice[ss]; not for Basic_op, Clk_duty, Clk_edge, Clk_freq, Clk_reset, Common_mode, Decision_delay, History_dep, Input_ref_noise, Kickback, MC_mismatch, Metastability, Off_set, Output_compat, PEX_Basic_op, PEX_Decision_delay, PEX_Kickback, PEX_Off_set, PEX_Power_energy, Power_energy, Reset_op, Trim_a, Trim_b
  ss_v1p98_tm40: temperature=-40; vcc=1.98; sky130.lib.spice[ss]; not for Basic_op, Clk_duty, Clk_edge, Clk_freq, Clk_reset, Common_mode, Decision_delay, History_dep, Input_ref_noise, Kickback, MC_mismatch, Metastability, Off_set, Output_compat, PEX_Basic_op, PEX_Decision_delay, PEX_Kickback, PEX_Off_set, PEX_Power_energy, Power_energy, Reset_op, Trim_a, Trim_b
  ss_v1p98_t27: temperature=27; vcc=1.98; sky130.lib.spice[ss]; not for Basic_op, Clk_duty, Clk_edge, Clk_freq, Clk_reset, Common_mode, Decision_delay, History_dep, Input_ref_noise, Kickback, MC_mismatch, Metastability, Off_set, Output_compat, PEX_Basic_op, PEX_Decision_delay, PEX_Kickback, PEX_Off_set, PEX_Power_energy, Power_energy, Reset_op, Trim_a, Trim_b
  ss_v1p98_t125: temperature=125; vcc=1.98; sky130.lib.spice[ss]; not for Basic_op, Clk_duty, Clk_edge, Clk_freq, Clk_reset, Common_mode, Decision_delay, History_dep, Input_ref_noise, Kickback, MC_mismatch, Metastability, Off_set, Output_compat, PEX_Basic_op, PEX_Decision_delay, PEX_Kickback, PEX_Off_set, PEX_Power_energy, Power_energy, Reset_op, Trim_a, Trim_b
  sf_v1p62_tm40: temperature=-40; vcc=1.62; sky130.lib.spice[sf]; not for Basic_op, Clk_duty, Clk_edge, Clk_freq, Clk_reset, Common_mode, Decision_delay, History_dep, Input_ref_noise, Kickback, MC_mismatch, Metastability, Off_set, Output_compat, PEX_Basic_op, PEX_Decision_delay, PEX_Kickback, PEX_Off_set, PEX_Power_energy, Power_energy, Reset_op, Trim_a, Trim_b
  sf_v1p62_t27: temperature=27; vcc=1.62; sky130.lib.spice[sf]; not for Basic_op, Clk_duty, Clk_edge, Clk_freq, Clk_reset, Common_mode, Decision_delay, History_dep, Input_ref_noise, Kickback, MC_mismatch, Metastability, Off_set, Output_compat, PEX_Basic_op, PEX_Decision_delay, PEX_Kickback, PEX_Off_set, PEX_Power_energy, Power_energy, Reset_op, Trim_a, Trim_b
  sf_v1p62_t125: temperature=125; vcc=1.62; sky130.lib.spice[sf]; not for Basic_op, Clk_duty, Clk_edge, Clk_freq, Clk_reset, Common_mode, Decision_delay, History_dep, Input_ref_noise, Kickback, MC_mismatch, Metastability, Off_set, Output_compat, PEX_Basic_op, PEX_Decision_delay, PEX_Kickback, PEX_Off_set, PEX_Power_energy, Power_energy, Reset_op, Trim_a, Trim_b
  sf_v1p8_tm40: temperature=-40; vcc=1.8; sky130.lib.spice[sf]; not for Basic_op, Clk_duty, Clk_edge, Clk_freq, Clk_reset, Common_mode, Decision_delay, History_dep, Input_ref_noise, Kickback, MC_mismatch, Metastability, Off_set, Output_compat, PEX_Basic_op, PEX_Decision_delay, PEX_Kickback, PEX_Off_set, PEX_Power_energy, Power_energy, Reset_op, Trim_a, Trim_b
  sf_v1p8_t27: temperature=27; vcc=1.8; sky130.lib.spice[sf]; not for Basic_op, Clk_duty, Clk_edge, Clk_freq, Clk_reset, Common_mode, Decision_delay, History_dep, Input_ref_noise, Kickback, MC_mismatch, Metastability, Off_set, Output_compat, PEX_Basic_op, PEX_Decision_delay, PEX_Kickback, PEX_Off_set, PEX_Power_energy, Power_energy, Reset_op, Trim_a, Trim_b
  sf_v1p8_t125: temperature=125; vcc=1.8; sky130.lib.spice[sf]; not for Basic_op, Clk_duty, Clk_edge, Clk_freq, Clk_reset, Common_mode, Decision_delay, History_dep, Input_ref_noise, Kickback, MC_mismatch, Metastability, Off_set, Output_compat, PEX_Basic_op, PEX_Decision_delay, PEX_Kickback, PEX_Off_set, PEX_Power_energy, Power_energy, Reset_op, Trim_a, Trim_b
  sf_v1p98_tm40: temperature=-40; vcc=1.98; sky130.lib.spice[sf]; not for Basic_op, Clk_duty, Clk_edge, Clk_freq, Clk_reset, Common_mode, Decision_delay, History_dep, Input_ref_noise, Kickback, MC_mismatch, Metastability, Off_set, Output_compat, PEX_Basic_op, PEX_Decision_delay, PEX_Kickback, PEX_Off_set, PEX_Power_energy, Power_energy, Reset_op, Trim_a, Trim_b
  sf_v1p98_t27: temperature=27; vcc=1.98; sky130.lib.spice[sf]; not for Basic_op, Clk_duty, Clk_edge, Clk_freq, Clk_reset, Common_mode, Decision_delay, History_dep, Input_ref_noise, Kickback, MC_mismatch, Metastability, Off_set, Output_compat, PEX_Basic_op, PEX_Decision_delay, PEX_Kickback, PEX_Off_set, PEX_Power_energy, Power_energy, Reset_op, Trim_a, Trim_b
  sf_v1p98_t125: temperature=125; vcc=1.98; sky130.lib.spice[sf]; not for Basic_op, Clk_duty, Clk_edge, Clk_freq, Clk_reset, Common_mode, Decision_delay, History_dep, Input_ref_noise, Kickback, MC_mismatch, Metastability, Off_set, Output_compat, PEX_Basic_op, PEX_Decision_delay, PEX_Kickback, PEX_Off_set, PEX_Power_energy, Power_energy, Reset_op, Trim_a, Trim_b
  fs_v1p62_tm40: temperature=-40; vcc=1.62; sky130.lib.spice[fs]; not for Basic_op, Clk_duty, Clk_edge, Clk_freq, Clk_reset, Common_mode, Decision_delay, History_dep, Input_ref_noise, Kickback, MC_mismatch, Metastability, Off_set, Output_compat, PEX_Basic_op, PEX_Decision_delay, PEX_Kickback, PEX_Off_set, PEX_Power_energy, Power_energy, Reset_op, Trim_a, Trim_b
  fs_v1p62_t27: temperature=27; vcc=1.62; sky130.lib.spice[fs]; not for Basic_op, Clk_duty, Clk_edge, Clk_freq, Clk_reset, Common_mode, Decision_delay, History_dep, Input_ref_noise, Kickback, MC_mismatch, Metastability, Off_set, Output_compat, PEX_Basic_op, PEX_Decision_delay, PEX_Kickback, PEX_Off_set, PEX_Power_energy, Power_energy, Reset_op, Trim_a, Trim_b
  fs_v1p62_t125: temperature=125; vcc=1.62; sky130.lib.spice[fs]; not for Basic_op, Clk_duty, Clk_edge, Clk_freq, Clk_reset, Common_mode, Decision_delay, History_dep, Input_ref_noise, Kickback, MC_mismatch, Metastability, Off_set, Output_compat, PEX_Basic_op, PEX_Decision_delay, PEX_Kickback, PEX_Off_set, PEX_Power_energy, Power_energy, Reset_op, Trim_a, Trim_b
  fs_v1p8_tm40: temperature=-40; vcc=1.8; sky130.lib.spice[fs]; not for Basic_op, Clk_duty, Clk_edge, Clk_freq, Clk_reset, Common_mode, Decision_delay, History_dep, Input_ref_noise, Kickback, MC_mismatch, Metastability, Off_set, Output_compat, PEX_Basic_op, PEX_Decision_delay, PEX_Kickback, PEX_Off_set, PEX_Power_energy, Power_energy, Reset_op, Trim_a, Trim_b
  fs_v1p8_t27: temperature=27; vcc=1.8; sky130.lib.spice[fs]; not for Basic_op, Clk_duty, Clk_edge, Clk_freq, Clk_reset, Common_mode, Decision_delay, History_dep, Input_ref_noise, Kickback, MC_mismatch, Metastability, Off_set, Output_compat, PEX_Basic_op, PEX_Decision_delay, PEX_Kickback, PEX_Off_set, PEX_Power_energy, Power_energy, Reset_op, Trim_a, Trim_b
  fs_v1p8_t125: temperature=125; vcc=1.8; sky130.lib.spice[fs]; not for Basic_op, Clk_duty, Clk_edge, Clk_freq, Clk_reset, Common_mode, Decision_delay, History_dep, Input_ref_noise, Kickback, MC_mismatch, Metastability, Off_set, Output_compat, PEX_Basic_op, PEX_Decision_delay, PEX_Kickback, PEX_Off_set, PEX_Power_energy, Power_energy, Reset_op, Trim_a, Trim_b
  fs_v1p98_tm40: temperature=-40; vcc=1.98; sky130.lib.spice[fs]; not for Basic_op, Clk_duty, Clk_edge, Clk_freq, Clk_reset, Common_mode, Decision_delay, History_dep, Input_ref_noise, Kickback, MC_mismatch, Metastability, Off_set, Output_compat, PEX_Basic_op, PEX_Decision_delay, PEX_Kickback, PEX_Off_set, PEX_Power_energy, Power_energy, Reset_op, Trim_a, Trim_b
  fs_v1p98_t27: temperature=27; vcc=1.98; sky130.lib.spice[fs]; not for Basic_op, Clk_duty, Clk_edge, Clk_freq, Clk_reset, Common_mode, Decision_delay, History_dep, Input_ref_noise, Kickback, MC_mismatch, Metastability, Off_set, Output_compat, PEX_Basic_op, PEX_Decision_delay, PEX_Kickback, PEX_Off_set, PEX_Power_energy, Power_energy, Reset_op, Trim_a, Trim_b
  fs_v1p98_t125: temperature=125; vcc=1.98; sky130.lib.spice[fs]; not for Basic_op, Clk_duty, Clk_edge, Clk_freq, Clk_reset, Common_mode, Decision_delay, History_dep, Input_ref_noise, Kickback, MC_mismatch, Metastability, Off_set, Output_compat, PEX_Basic_op, PEX_Decision_delay, PEX_Kickback, PEX_Off_set, PEX_Power_energy, Power_energy, Reset_op, Trim_a, Trim_b
Specs:
  Basic_op / dec_pos: > 0.5
  Basic_op / dec_neg: < -0.5
  Basic_op / n_wrong: < 1
  Basic_op / n_unres: < 1
  Reset_op / outp_rst: > 0.95
  Reset_op / outn_rst: > 0.95
  Reset_op / net2_rst: > 0.9
  Reset_op / net3_rst: > 0.9
  Reset_op / t_reset_frac: < 0.5
  Off_set / Vos: range -5m to 5m
  Input_ref_noise / sigma_n: < 1.75m
  Decision_delay / t_cq_frac: < 1
  Metastability / n_unres: < 1
  Common_mode / Vos: range -5m to 5m
  Common_mode / n_unres: < 1
  Kickback / kick_diff: < 3.5m
  History_dep / dVth_hist: range -1m to 1m
  Clk_freq / n_wrong: < 1
  Clk_freq / n_unres: < 1
  Clk_edge / n_wrong: < 1
  Clk_edge / n_unres: < 1
  Clk_duty / n_wrong: < 1
  Clk_duty / n_unres: < 1
  Clk_reset / n_wrong: < 1
  Clk_reset / n_unres: < 1
  Output_compat / V_high: > 0.9
  Output_compat / V_low: < 0.1
  Output_compat / V_peak: < 1.1
  Output_compat / V_undershoot: > -0.1
  Output_compat / setup_margin: > 0
  Output_compat / n_unres: < 1
  PVT / Vos: range -5m to 5m
  PVT / n_unres: < 1
  PEX_Basic_op / dec_pos: > 0.5
  PEX_Basic_op / dec_neg: < -0.5
  PEX_Basic_op / n_wrong: < 1
  PEX_Basic_op / n_unres: < 1
  PEX_Off_set / Vos: range -5m to 5m
  PEX_Decision_delay / t_cq_frac: < 1
  PEX_Kickback / kick_diff: < 3.5m
Disabled tests: Clk_duty, Clk_edge, Clk_freq, Clk_reset, Common_mode, Decision_delay, History_dep, Input_ref_noise, Kickback, MC_mismatch, Metastability, Off_set, Output_compat, PEX_Basic_op, PEX_Decision_delay, PEX_Kickback, PEX_Off_set, PEX_Power_energy, PVT, Power_energy, Reset_op, Trim_a, Trim_b
