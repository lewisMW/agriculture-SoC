ADE simulation setup
Run mode: Single Run, Sweeps and Corners
Tests:
  Basic_op: sar_adc/tb_comparator_parasitic/schematic, simulator spectre
    Variables: vcc = 1.8; vcm = 0.9; vd = 5m 20m 100m; fclk = 1M; duty = 0.5; tr = 100p; tf = 100p; trim_a = 8; trim_b = 8; rs = 1; ccdac = 9.3p; cload = 10f; mode = 2; vstart = -30m; vstep = 1m; nsteps = 61; nrep = 1; vagg = 300m; tsu = 0.5n; pol = 1; vos = 0; ncyc = 8; tstop = (ncyc+1)/fclk
  Reset_op (off): sar_adc/tb_comparator_parasitic/schematic, simulator spectre
    Variables: vcc = 1.8; vcm = 0.9; vd = 100m; fclk = 1M; duty = 0.5; tr = 100p; tf = 100p; trim_a = 8; trim_b = 8; rs = 1; ccdac = 9.3p; cload = 10f; mode = 0; vstart = -30m; vstep = 1m; nsteps = 61; nrep = 1; vagg = 300m; tsu = 0.5n; pol = -1; vos = 0; ncyc = 6; tstop = (ncyc+1)/fclk
  Off_set (off): sar_adc/tb_comparator_parasitic/schematic, simulator spectre
    Variables: vcc = 1.8; vcm = 0.9; vd = 10m; fclk = 1M; duty = 0.5; tr = 100p; tf = 100p; trim_a = 8; trim_b = 8; rs = 1; ccdac = 9.3p; cload = 10f; mode = 1; vstart = -30m; vstep = 0.25m; nsteps = 241; nrep = 1; vagg = 300m; tsu = 0.5n; pol = -1; vos = 0; ncyc = nsteps*nrep; tstop = (ncyc+1)/fclk
  Input_ref_noise (off): sar_adc/tb_comparator_parasitic/schematic, simulator spectre
    Variables: vcc = 1.8; vcm = 0.9; vd = 10m; fclk = 5M; duty = 0.5; tr = 100p; tf = 100p; trim_a = 8; trim_b = 8; rs = 1; ccdac = 9.3p; cload = 10f; mode = 1; vstart = -3m; vstep = 0.25m; nsteps = 25; nrep = 20; vagg = 300m; tsu = 0.5n; pol = -1; vos = 0; ncyc = nsteps*nrep; tstop = (ncyc+1)/fclk
  Decision_delay (off): sar_adc/tb_comparator_parasitic/schematic, simulator spectre
    Variables: vcc = 1.8; vcm = 0.9; vd = -100m -10m -1m 1m 3m 10m 30m 100m 300m; fclk = 1M; duty = 0.5; tr = 100p; tf = 100p; trim_a = 8; trim_b = 8; rs = 1; ccdac = 9.3p; cload = 10f; mode = 0; vstart = -30m; vstep = 1m; nsteps = 61; nrep = 1; vagg = 300m; tsu = 0.5n; pol = -1; vos = 0; ncyc = 6; tstop = (ncyc+1)/fclk
  Metastability (off): sar_adc/tb_comparator_parasitic/schematic, simulator spectre
    Variables: vcc = 1.8; vcm = 0.9; vd = 10m; fclk = 1M 5M 20M; duty = 0.5; tr = 100p; tf = 100p; trim_a = 8; trim_b = 8; rs = 1; ccdac = 9.3p; cload = 10f; mode = 1; vstart = vos-50u; vstep = 1u; nsteps = 101; nrep = 1; vagg = 300m; tsu = 0.5n; pol = -1; vos = -125u; ncyc = nsteps*nrep; tstop = (ncyc+1)/fclk
  Common_mode (off): sar_adc/tb_comparator_parasitic/schematic, simulator spectre
    Variables: vcc = 1.8; vcm = 0.3 0.5 0.7 0.9 1.1 1.3 1.5; vd = 10m; fclk = 1M; duty = 0.5; tr = 100p; tf = 100p; trim_a = 8; trim_b = 8; rs = 1; ccdac = 9.3p; cload = 10f; mode = 1; vstart = -30m; vstep = 1m; nsteps = 61; nrep = 1; vagg = 300m; tsu = 0.5n; pol = -1; vos = 0; ncyc = nsteps*nrep; tstop = (ncyc+1)/fclk
  Kickback (off): sar_adc/tb_comparator_parasitic/schematic, simulator spectre
    Variables: vcc = 1.8; vcm = 0.9; vd = 1m 100m; fclk = 1M; duty = 0.5; tr = 100p; tf = 100p; trim_a = 8; trim_b = 8; rs = 1G; ccdac = 9.3p 1p 100f; cload = 10f; mode = 0; vstart = -30m; vstep = 1m; nsteps = 61; nrep = 1; vagg = 300m; tsu = 0.5n; pol = -1; vos = 0; ncyc = 8; tstop = (ncyc+1)/fclk
  Power_energy (off): sar_adc/tb_comparator_parasitic/schematic, simulator spectre
    Variables: vcc = 1.8; vcm = 0.9; vd = 1m 10m 100m; fclk = 1M; duty = 0.5; tr = 100p; tf = 100p; trim_a = 8; trim_b = 8; rs = 1; ccdac = 9.3p; cload = 10f; mode = 2; vstart = -30m; vstep = 1m; nsteps = 61; nrep = 1; vagg = 300m; tsu = 0.5n; pol = -1; vos = 0; ncyc = 16; tstop = (ncyc+1)/fclk
  History_dep (off): sar_adc/tb_comparator_parasitic/schematic, simulator spectre
    Variables: vcc = 1.8; vcm = 0.9; vd = 10m; fclk = 1M; duty = 0.5; tr = 100p; tf = 100p; trim_a = 8; trim_b = 8; rs = 1; ccdac = 9.3p; cload = 10f; mode = 3; vstart = -10m; vstep = 0.25m; nsteps = 81; nrep = 1; vagg = 300m; tsu = 0.5n; pol = -1; vos = 0; ncyc = 324; tstop = (ncyc+1)/fclk
  Clk_freq (off): sar_adc/tb_comparator_parasitic/schematic, simulator spectre
    Variables: vcc = 1.8; vcm = 0.9; vd = 10m; fclk = 1M 2M 5M 10M 20M 50M 100M; duty = 0.5; tr = 100p; tf = 100p; trim_a = 8; trim_b = 8; rs = 1; ccdac = 9.3p; cload = 10f; mode = 2; vstart = -30m; vstep = 1m; nsteps = 61; nrep = 1; vagg = 300m; tsu = 0.5n; pol = -1; vos = 0; ncyc = 8; tstop = (ncyc+1)/fclk
  Clk_edge (off): sar_adc/tb_comparator_parasitic/schematic, simulator spectre
    Variables: vcc = 1.8; vcm = 0.9; vd = 10m; fclk = 1M; duty = 0.5; tr = 50p 200p 1n 5n; tf = tr; trim_a = 8; trim_b = 8; rs = 1; ccdac = 9.3p; cload = 10f; mode = 2; vstart = -30m; vstep = 1m; nsteps = 61; nrep = 1; vagg = 300m; tsu = 0.5n; pol = -1; vos = 0; ncyc = 8; tstop = (ncyc+1)/fclk
  Clk_duty (off): sar_adc/tb_comparator_parasitic/schematic, simulator spectre
    Variables: vcc = 1.8; vcm = 0.9; vd = 10m; fclk = 1M; duty = 0.2 0.3 0.4 0.5 0.6 0.7 0.8; tr = 100p; tf = 100p; trim_a = 8; trim_b = 8; rs = 1; ccdac = 9.3p; cload = 10f; mode = 2; vstart = -30m; vstep = 1m; nsteps = 61; nrep = 1; vagg = 300m; tsu = 0.5n; pol = -1; vos = 0; ncyc = 8; tstop = (ncyc+1)/fclk
  Clk_reset (off): sar_adc/tb_comparator_parasitic/schematic, simulator spectre
    Variables: vcc = 1.8; vcm = 0.9; vd = 10m; fclk = 1/(t_eval+t_rst); duty = t_eval/(t_eval+t_rst); tr = 100p; tf = 100p; trim_a = 8; trim_b = 8; rs = 1; ccdac = 9.3p; cload = 10f; mode = 2; vstart = -30m; vstep = 1m; nsteps = 61; nrep = 1; vagg = 300m; tsu = 0.5n; pol = -1; vos = 0; ncyc = 8; tstop = (ncyc+1)/fclk; t_rst = 1n 2n 5n 10n 50n 200n 500n; t_eval = 500n
  Output_compat (off): sar_adc/tb_comparator_parasitic/schematic, simulator spectre
    Variables: vcc = 1.8; vcm = 0.9; vd = 10m; fclk = 1M; duty = 0.5; tr = 100p; tf = 100p; trim_a = 8; trim_b = 8; rs = 1; ccdac = 9.3p; cload = 5f 10f 50f; mode = 2; vstart = -30m; vstep = 1m; nsteps = 61; nrep = 1; vagg = 300m; tsu = 0.5n; pol = -1; vos = 0; ncyc = 8; tstop = (ncyc+1)/fclk
  PVT (off): sar_adc/tb_comparator_parasitic/schematic, simulator spectre
    Variables: vcc = 1.8; vcm = 0.9; vd = 10m; fclk = 1M; duty = 0.5; tr = 100p; tf = 100p; trim_a = 8; trim_b = 8; rs = 1; ccdac = 9.3p; cload = 10f; mode = 1; vstart = -30m; vstep = 1m; nsteps = 61; nrep = 1; vagg = 300m; tsu = 0.5n; pol = -1; vos = 0; ncyc = nsteps*nrep; tstop = (ncyc+1)/fclk
  MC_mismatch (off): sar_adc/tb_comparator_parasitic/schematic, simulator spectre
    Variables: vcc = 1.8; vcm = 0.9; vd = 10m; fclk = 1M; duty = 0.5; tr = 100p; tf = 100p; trim_a = 8; trim_b = 8; rs = 1; ccdac = 9.3p; cload = 10f; mode = 1; vstart = -60m; vstep = 1m; nsteps = 121; nrep = 1; vagg = 300m; tsu = 0.5n; pol = -1; vos = 0; ncyc = nsteps*nrep; tstop = (ncyc+1)/fclk
  Trim_a (off): sar_adc/tb_comparator_parasitic/schematic, simulator spectre
    Variables: vcc = 1.8; vcm = 0.9; vd = 10m; fclk = 1M; duty = 0.5; tr = 100p; tf = 100p; trim_a = 0:1:31; trim_b = 8; rs = 1; ccdac = 9.3p; cload = 10f; mode = 1; vstart = -30m; vstep = 1m; nsteps = 61; nrep = 1; vagg = 300m; tsu = 0.5n; pol = -1; vos = 0; ncyc = nsteps*nrep; tstop = (ncyc+1)/fclk
  Trim_b (off): sar_adc/tb_comparator_parasitic/schematic, simulator spectre
    Variables: vcc = 1.8; vcm = 0.9; vd = 10m; fclk = 1M; duty = 0.5; tr = 100p; tf = 100p; trim_a = 8; trim_b = 0:1:31; rs = 1; ccdac = 9.3p; cload = 10f; mode = 1; vstart = -30m; vstep = 1m; nsteps = 61; nrep = 1; vagg = 300m; tsu = 0.5n; pol = -1; vos = 0; ncyc = nsteps*nrep; tstop = (ncyc+1)/fclk
  PEX_Basic_op (off): sar_adc/tb_comparator_parasitic/config_pex, simulator spectre
    Variables: vcc = 1.8; vcm = 0.9; vd = 5m 20m 100m; fclk = 1M; duty = 0.5; tr = 100p; tf = 100p; trim_a = 8; trim_b = 8; rs = 1; ccdac = 9.3p; cload = 10f; mode = 2; vstart = -30m; vstep = 1m; nsteps = 61; nrep = 1; vagg = 300m; tsu = 0.5n; pol = 1; vos = 0; ncyc = 8; tstop = (ncyc+1)/fclk
  PEX_Off_set (off): sar_adc/tb_comparator_parasitic/config_pex, simulator spectre
    Variables: vcc = 1.8; vcm = 0.9; vd = 10m; fclk = 1M; duty = 0.5; tr = 100p; tf = 100p; trim_a = 8; trim_b = 8; rs = 1; ccdac = 9.3p; cload = 10f; mode = 1; vstart = -30m; vstep = 0.25m; nsteps = 241; nrep = 1; vagg = 300m; tsu = 0.5n; pol = -1; vos = 0; ncyc = nsteps*nrep; tstop = (ncyc+1)/fclk
  PEX_Decision_delay (off): sar_adc/tb_comparator_parasitic/config_pex, simulator spectre
    Variables: vcc = 1.8; vcm = 0.9; vd = -100m -10m -1m 1m 3m 10m 30m 100m 300m; fclk = 1M; duty = 0.5; tr = 100p; tf = 100p; trim_a = 8; trim_b = 8; rs = 1; ccdac = 9.3p; cload = 10f; mode = 0; vstart = -30m; vstep = 1m; nsteps = 61; nrep = 1; vagg = 300m; tsu = 0.5n; pol = -1; vos = 0; ncyc = 6; tstop = (ncyc+1)/fclk
  PEX_Kickback (off): sar_adc/tb_comparator_parasitic/config_pex, simulator spectre
    Variables: vcc = 1.8; vcm = 0.9; vd = 1m 100m; fclk = 1M; duty = 0.5; tr = 100p; tf = 100p; trim_a = 8; trim_b = 8; rs = 1G; ccdac = 9.3p 1p 100f; cload = 10f; mode = 0; vstart = -30m; vstep = 1m; nsteps = 61; nrep = 1; vagg = 300m; tsu = 0.5n; pol = -1; vos = 0; ncyc = 8; tstop = (ncyc+1)/fclk
  PEX_Power_energy (off): sar_adc/tb_comparator_parasitic/config_pex, simulator spectre
    Variables: vcc = 1.8; vcm = 0.9; vd = 1m 10m 100m; fclk = 1M; duty = 0.5; tr = 100p; tf = 100p; trim_a = 8; trim_b = 8; rs = 1; ccdac = 9.3p; cload = 10f; mode = 2; vstart = -30m; vstep = 1m; nsteps = 61; nrep = 1; vagg = 300m; tsu = 0.5n; pol = -1; vos = 0; ncyc = 16; tstop = (ncyc+1)/fclk
Corners:
  model folders: /home/admin/Documents/PDKs/sky130_release_0.1.0/models
  tt_v1p62_tm40: temperature=-40; vcc=1.62; sky130.lib.spice[tt]; not for Basic_op, Clk_duty, Clk_edge, Clk_freq, Clk_reset, Common_mode, Decision_delay, History_dep, Input_ref_noise, Kickback, MC_mismatch, Metastability, Off_set, Output_compat, PEX_Basic_op, PEX_Decision_delay, PEX_Kickback, PEX_Off_set, PEX_Power_energy, Power_energy, Reset_op, Trim_a, Trim_b
  tt_v1p62_t27: temperature=27; vcc=1.62; sky130.lib.spice[tt]; not for Basic_op, Clk_duty, Clk_edge, Clk_freq, Clk_reset, Common_mode, Decision_delay, History_dep, Input_ref_noise, Kickback, MC_mismatch, Metastability, Off_set, Output_compat, PEX_Basic_op, PEX_Decision_delay, PEX_Kickback, PEX_Off_set, PEX_Power_energy, Power_energy, Reset_op, Trim_a, Trim_b
  tt_v1p62_t125: temperature=125; vcc=1.62; sky130.lib.spice[tt]; not for Basic_op, Clk_duty, Clk_edge, Clk_freq, Clk_reset, Common_mode, Decision_delay, History_dep, Input_ref_noise, Kickback, MC_mismatch, Metastability, Off_set, Output_compat, PEX_Basic_op, PEX_Decision_delay, PEX_Kickback, PEX_Off_set, PEX_Power_energy, Power_energy, Reset_op, Trim_a, Trim_b
  tt_v1p8_tm40: temperature=-40; vcc=1.8; sky130.lib.spice[tt]; not for Basic_op, Clk_duty, Clk_edge, Clk_freq, Clk_reset, Common_mode, Decision_delay, History_dep, Input_ref_noise, Kickback, MC_mismatch, Metastability, Off_set, Output_compat, PEX_Basic_op, PEX_Decision_delay, PEX_Kickback, PEX_Off_set, PEX_Power_energy, Power_energy, Reset_op, Trim_a, Trim_b
  tt_v1p8_t27: temperature=27; vcc=1.8; sky130.lib.spice[tt]; not for Basic_op, Clk_duty, Clk_edge, Clk_freq, Clk_reset, Common_mode, Decision_delay, History_dep, Input_ref_noise, Kickback, MC_mismatch, Metastability, Off_set, Output_compat, PEX_Basic_op, PEX_Decision_delay, PEX_Kickback, PEX_Off_set, PEX_Power_energy, Power_energy, Reset_op, Trim_a, Trim_b
  tt_v1p8_t125: temperature=125; vcc=1.8; sky130.lib.spice[tt]; not for Basic_op, Clk_duty, Clk_edge, Clk_freq, Clk_reset, Common_mode, Decision_delay, History_dep, Input_ref_noise, Kickback, MC_mismatch, Metastability, Off_set, Output_compat, PEX_Basic_op, PEX_Decision_delay, PEX_Kickback, PEX_Off_set, PEX_Power_energy, Power_energy, Reset_op, Trim_a, Trim_b
  tt_v1p98_tm40: temperature=-40; vcc=1.98; sky130.lib.spice[tt]; not for Basic_op, Clk_duty, Clk_edge, Clk_freq, Clk_reset, Common_mode, Decision_delay, History_dep, Input_ref_noise, Kickback, MC_mismatch, Metastability, Off_set, Output_compat, PEX_Basic_op, PEX_Decision_delay, PEX_Kickback, PEX_Off_set, PEX_Power_energy, Power_energy, Reset_op, Trim_a, Trim_b
  tt_v1p98_t27: temperature=27; vcc=1.98; sky130.lib.spice[tt]; not for Basic_op, Clk_duty, Clk_edge, Clk_freq, Clk_reset, Common_mode, Decision_delay, History_dep, Input_ref_noise, Kickback, MC_mismatch, Metastability, Off_set, Output_compat, PEX_Basic_op, PEX_Decision_delay, PEX_Kickback, PEX_Off_set, PEX_Power_energy, Power_energy, Reset_op, Trim_a, Trim_b
  tt_v1p98_t125: temperature=125; vcc=1.98; sky130.lib.spice[tt]; not for Basic_op, Clk_duty, Clk_edge, Clk_freq, Clk_reset, Common_mode, Decision_delay, History_dep, Input_ref_noise, Kickback, MC_mismatch, Metastability, Off_set, Output_compat, PEX_Basic_op, PEX_Decision_delay, PEX_Kickback, PEX_Off_set, PEX_Power_energy, Power_energy, Reset_op, Trim_a, Trim_b
  ff_v1p62_tm40: temperature=-40; vcc=1.62; sky130.lib.spice[ff]; not for Basic_op, Clk_duty, Clk_edge, Clk_freq, Clk_reset, Common_mode, Decision_delay, History_dep, Input_ref_noise, Kickback, MC_mismatch, Metastability, Off_set, Output_compat, PEX_Basic_op, PEX_Decision_delay, PEX_Kickback, PEX_Off_set, PEX_Power_energy, Power_energy, Reset_op, Trim_a, Trim_b
  ff_v1p62_t27: temperature=27; vcc=1.62; sky130.lib.spice[ff]; not for Basic_op, Clk_duty, Clk_edge, Clk_freq, Clk_reset, Common_mode, Decision_delay, History_dep, Input_ref_noise, Kickback, MC_mismatch, Metastability, Off_set, Output_compat, PEX_Basic_op, PEX_Decision_delay, PEX_Kickback, PEX_Off_set, PEX_Power_energy, Power_energy, Reset_op, Trim_a, Trim_b
  ff_v1p62_t125: temperature=125; vcc=1.62; sky130.lib.spice[ff]; not for Basic_op, Clk_duty, Clk_edge, Clk_freq, Clk_reset, Common_mode, Decision_delay, History_dep, Input_ref_noise, Kickback, MC_mismatch, Metastability, Off_set, Output_compat, PEX_Basic_op, PEX_Decision_delay, PEX_Kickback, PEX_Off_set, PEX_Power_energy, Power_energy, Reset_op, Trim_a, Trim_b
  ff_v1p8_tm40: temperature=-40; vcc=1.8; sky130.lib.spice[ff]; not for Basic_op, Clk_duty, Clk_edge, Clk_freq, Clk_reset, Common_mode, Decision_delay, History_dep, Input_ref_noise, Kickback, MC_mismatch, Metastability, Off_set, Output_compat, PEX_Basic_op, PEX_Decision_delay, PEX_Kickback, PEX_Off_set, PEX_Power_energy, Power_energy, Reset_op, Trim_a, Trim_b
  ff_v1p8_t27: temperature=27; vcc=1.8; sky130.lib.spice[ff]; not for Basic_op, Clk_duty, Clk_edge, Clk_freq, Clk_reset, Common_mode, Decision_delay, History_dep, Input_ref_noise, Kickback, MC_mismatch, Metastability, Off_set, Output_compat, PEX_Basic_op, PEX_Decision_delay, PEX_Kickback, PEX_Off_set, PEX_Power_energy, Power_energy, Reset_op, Trim_a, Trim_b
  ff_v1p8_t125: temperature=125; vcc=1.8; sky130.lib.spice[ff]; not for Basic_op, Clk_duty, Clk_edge, Clk_freq, Clk_reset, Common_mode, Decision_delay, History_dep, Input_ref_noise, Kickback, MC_mismatch, Metastability, Off_set, Output_compat, PEX_Basic_op, PEX_Decision_delay, PEX_Kickback, PEX_Off_set, PEX_Power_energy, Power_energy, Reset_op, Trim_a, Trim_b
  ff_v1p98_tm40: temperature=-40; vcc=1.98; sky130.lib.spice[ff]; not for Basic_op, Clk_duty, Clk_edge, Clk_freq, Clk_reset, Common_mode, Decision_delay, History_dep, Input_ref_noise, Kickback, MC_mismatch, Metastability, Off_set, Output_compat, PEX_Basic_op, PEX_Decision_delay, PEX_Kickback, PEX_Off_set, PEX_Power_energy, Power_energy, Reset_op, Trim_a, Trim_b
  ff_v1p98_t27: temperature=27; vcc=1.98; sky130.lib.spice[ff]; not for Basic_op, Clk_duty, Clk_edge, Clk_freq, Clk_reset, Common_mode, Decision_delay, History_dep, Input_ref_noise, Kickback, MC_mismatch, Metastability, Off_set, Output_compat, PEX_Basic_op, PEX_Decision_delay, PEX_Kickback, PEX_Off_set, PEX_Power_energy, Power_energy, Reset_op, Trim_a, Trim_b
  ff_v1p98_t125: temperature=125; vcc=1.98; sky130.lib.spice[ff]; not for Basic_op, Clk_duty, Clk_edge, Clk_freq, Clk_reset, Common_mode, Decision_delay, History_dep, Input_ref_noise, Kickback, MC_mismatch, Metastability, Off_set, Output_compat, PEX_Basic_op, PEX_Decision_delay, PEX_Kickback, PEX_Off_set, PEX_Power_energy, Power_energy, Reset_op, Trim_a, Trim_b
  ss_v1p62_tm40: temperature=-40; vcc=1.62; sky130.lib.spice[ss]; not for Basic_op, Clk_duty, Clk_edge, Clk_freq, Clk_reset, Common_mode, Decision_delay, History_dep, Input_ref_noise, Kickback, MC_mismatch, Metastability, Off_set, Output_compat, PEX_Basic_op, PEX_Decision_delay, PEX_Kickback, PEX_Off_set, PEX_Power_energy, Power_energy, Reset_op, Trim_a, Trim_b
  ss_v1p62_t27: temperature=27; vcc=1.62; sky130.lib.spice[ss]; not for Basic_op, Clk_duty, Clk_edge, Clk_freq, Clk_reset, Common_mode, Decision_delay, History_dep, Input_ref_noise, Kickback, MC_mismatch, Metastability, Off_set, Output_compat, PEX_Basic_op, PEX_Decision_delay, PEX_Kickback, PEX_Off_set, PEX_Power_energy, Power_energy, Reset_op, Trim_a, Trim_b
  ss_v1p62_t125: temperature=125; vcc=1.62; sky130.lib.spice[ss]; not for Basic_op, Clk_duty, Clk_edge, Clk_freq, Clk_reset, Common_mode, Decision_delay, History_dep, Input_ref_noise, Kickback, MC_mismatch, Metastability, Off_set, Output_compat, PEX_Basic_op, PEX_Decision_delay, PEX_Kickback, PEX_Off_set, PEX_Power_energy, Power_energy, Reset_op, Trim_a, Trim_b
  ss_v1p8_tm40: temperature=-40; vcc=1.8; sky130.lib.spice[ss]; not for Basic_op, Clk_duty, Clk_edge, Clk_freq, Clk_reset, Common_mode, Decision_delay, History_dep, Input_ref_noise, Kickback, MC_mismatch, Metastability, Off_set, Output_compat, PEX_Basic_op, PEX_Decision_delay, PEX_Kickback, PEX_Off_set, PEX_Power_energy, Power_energy, Reset_op, Trim_a, Trim_b
  ss_v1p8_t27: temperature=27; vcc=1.8; sky130.lib.spice[ss]; not for Basic_op, Clk_duty, Clk_edge, Clk_freq, Clk_reset, Common_mode, Decision_delay, History_dep, Input_ref_noise, Kickback, MC_mismatch, Metastability, Off_set, Output_compat, PEX_Basic_op, PEX_Decision_delay, PEX_Kickback, PEX_Off_set, PEX_Power_energy, Power_energy, Reset_op, Trim_a, Trim_b
  ss_v1p8_t125: temperature=125; vcc=1.8; sky130.lib.spice[ss]; not for Basic_op, Clk_duty, Clk_edge, Clk_freq, Clk_reset, Common_mode, Decision_delay, History_dep, Input_ref_noise, Kickback, MC_mismatch, Metastability, Off_set, Output_compat, PEX_Basic_op, PEX_Decision_delay, PEX_Kickback, PEX_Off_set, PEX_Power_energy, Power_energy, Reset_op, Trim_a, Trim_b
  ss_v1p98_tm40: temperature=-40; vcc=1.98; sky130.lib.spice[ss]; not for Basic_op, Clk_duty, Clk_edge, Clk_freq, Clk_reset, Common_mode, Decision_delay, History_dep, Input_ref_noise, Kickback, MC_mismatch, Metastability, Off_set, Output_compat, PEX_Basic_op, PEX_Decision_delay, PEX_Kickback, PEX_Off_set, PEX_Power_energy, Power_energy, Reset_op, Trim_a, Trim_b
  ss_v1p98_t27: temperature=27; vcc=1.98; sky130.lib.spice[ss]; not for Basic_op, Clk_duty, Clk_edge, Clk_freq, Clk_reset, Common_mode, Decision_delay, History_dep, Input_ref_noise, Kickback, MC_mismatch, Metastability, Off_set, Output_compat, PEX_Basic_op, PEX_Decision_delay, PEX_Kickback, PEX_Off_set, PEX_Power_energy, Power_energy, Reset_op, Trim_a, Trim_b
  ss_v1p98_t125: temperature=125; vcc=1.98; sky130.lib.spice[ss]; not for Basic_op, Clk_duty, Clk_edge, Clk_freq, Clk_reset, Common_mode, Decision_delay, History_dep, Input_ref_noise, Kickback, MC_mismatch, Metastability, Off_set, Output_compat, PEX_Basic_op, PEX_Decision_delay, PEX_Kickback, PEX_Off_set, PEX_Power_energy, Power_energy, Reset_op, Trim_a, Trim_b
  sf_v1p62_tm40: temperature=-40; vcc=1.62; sky130.lib.spice[sf]; not for Basic_op, Clk_duty, Clk_edge, Clk_freq, Clk_reset, Common_mode, Decision_delay, History_dep, Input_ref_noise, Kickback, MC_mismatch, Metastability, Off_set, Output_compat, PEX_Basic_op, PEX_Decision_delay, PEX_Kickback, PEX_Off_set, PEX_Power_energy, Power_energy, Reset_op, Trim_a, Trim_b
  sf_v1p62_t27: temperature=27; vcc=1.62; sky130.lib.spice[sf]; not for Basic_op, Clk_duty, Clk_edge, Clk_freq, Clk_reset, Common_mode, Decision_delay, History_dep, Input_ref_noise, Kickback, MC_mismatch, Metastability, Off_set, Output_compat, PEX_Basic_op, PEX_Decision_delay, PEX_Kickback, PEX_Off_set, PEX_Power_energy, Power_energy, Reset_op, Trim_a, Trim_b
  sf_v1p62_t125: temperature=125; vcc=1.62; sky130.lib.spice[sf]; not for Basic_op, Clk_duty, Clk_edge, Clk_freq, Clk_reset, Common_mode, Decision_delay, History_dep, Input_ref_noise, Kickback, MC_mismatch, Metastability, Off_set, Output_compat, PEX_Basic_op, PEX_Decision_delay, PEX_Kickback, PEX_Off_set, PEX_Power_energy, Power_energy, Reset_op, Trim_a, Trim_b
  sf_v1p8_tm40: temperature=-40; vcc=1.8; sky130.lib.spice[sf]; not for Basic_op, Clk_duty, Clk_edge, Clk_freq, Clk_reset, Common_mode, Decision_delay, History_dep, Input_ref_noise, Kickback, MC_mismatch, Metastability, Off_set, Output_compat, PEX_Basic_op, PEX_Decision_delay, PEX_Kickback, PEX_Off_set, PEX_Power_energy, Power_energy, Reset_op, Trim_a, Trim_b
  sf_v1p8_t27: temperature=27; vcc=1.8; sky130.lib.spice[sf]; not for Basic_op, Clk_duty, Clk_edge, Clk_freq, Clk_reset, Common_mode, Decision_delay, History_dep, Input_ref_noise, Kickback, MC_mismatch, Metastability, Off_set, Output_compat, PEX_Basic_op, PEX_Decision_delay, PEX_Kickback, PEX_Off_set, PEX_Power_energy, Power_energy, Reset_op, Trim_a, Trim_b
  sf_v1p8_t125: temperature=125; vcc=1.8; sky130.lib.spice[sf]; not for Basic_op, Clk_duty, Clk_edge, Clk_freq, Clk_reset, Common_mode, Decision_delay, History_dep, Input_ref_noise, Kickback, MC_mismatch, Metastability, Off_set, Output_compat, PEX_Basic_op, PEX_Decision_delay, PEX_Kickback, PEX_Off_set, PEX_Power_energy, Power_energy, Reset_op, Trim_a, Trim_b
  sf_v1p98_tm40: temperature=-40; vcc=1.98; sky130.lib.spice[sf]; not for Basic_op, Clk_duty, Clk_edge, Clk_freq, Clk_reset, Common_mode, Decision_delay, History_dep, Input_ref_noise, Kickback, MC_mismatch, Metastability, Off_set, Output_compat, PEX_Basic_op, PEX_Decision_delay, PEX_Kickback, PEX_Off_set, PEX_Power_energy, Power_energy, Reset_op, Trim_a, Trim_b
  sf_v1p98_t27: temperature=27; vcc=1.98; sky130.lib.spice[sf]; not for Basic_op, Clk_duty, Clk_edge, Clk_freq, Clk_reset, Common_mode, Decision_delay, History_dep, Input_ref_noise, Kickback, MC_mismatch, Metastability, Off_set, Output_compat, PEX_Basic_op, PEX_Decision_delay, PEX_Kickback, PEX_Off_set, PEX_Power_energy, Power_energy, Reset_op, Trim_a, Trim_b
  sf_v1p98_t125: temperature=125; vcc=1.98; sky130.lib.spice[sf]; not for Basic_op, Clk_duty, Clk_edge, Clk_freq, Clk_reset, Common_mode, Decision_delay, History_dep, Input_ref_noise, Kickback, MC_mismatch, Metastability, Off_set, Output_compat, PEX_Basic_op, PEX_Decision_delay, PEX_Kickback, PEX_Off_set, PEX_Power_energy, Power_energy, Reset_op, Trim_a, Trim_b
  fs_v1p62_tm40: temperature=-40; vcc=1.62; sky130.lib.spice[fs]; not for Basic_op, Clk_duty, Clk_edge, Clk_freq, Clk_reset, Common_mode, Decision_delay, History_dep, Input_ref_noise, Kickback, MC_mismatch, Metastability, Off_set, Output_compat, PEX_Basic_op, PEX_Decision_delay, PEX_Kickback, PEX_Off_set, PEX_Power_energy, Power_energy, Reset_op, Trim_a, Trim_b
  fs_v1p62_t27: temperature=27; vcc=1.62; sky130.lib.spice[fs]; not for Basic_op, Clk_duty, Clk_edge, Clk_freq, Clk_reset, Common_mode, Decision_delay, History_dep, Input_ref_noise, Kickback, MC_mismatch, Metastability, Off_set, Output_compat, PEX_Basic_op, PEX_Decision_delay, PEX_Kickback, PEX_Off_set, PEX_Power_energy, Power_energy, Reset_op, Trim_a, Trim_b
  fs_v1p62_t125: temperature=125; vcc=1.62; sky130.lib.spice[fs]; not for Basic_op, Clk_duty, Clk_edge, Clk_freq, Clk_reset, Common_mode, Decision_delay, History_dep, Input_ref_noise, Kickback, MC_mismatch, Metastability, Off_set, Output_compat, PEX_Basic_op, PEX_Decision_delay, PEX_Kickback, PEX_Off_set, PEX_Power_energy, Power_energy, Reset_op, Trim_a, Trim_b
  fs_v1p8_tm40: temperature=-40; vcc=1.8; sky130.lib.spice[fs]; not for Basic_op, Clk_duty, Clk_edge, Clk_freq, Clk_reset, Common_mode, Decision_delay, History_dep, Input_ref_noise, Kickback, MC_mismatch, Metastability, Off_set, Output_compat, PEX_Basic_op, PEX_Decision_delay, PEX_Kickback, PEX_Off_set, PEX_Power_energy, Power_energy, Reset_op, Trim_a, Trim_b
  fs_v1p8_t27: temperature=27; vcc=1.8; sky130.lib.spice[fs]; not for Basic_op, Clk_duty, Clk_edge, Clk_freq, Clk_reset, Common_mode, Decision_delay, History_dep, Input_ref_noise, Kickback, MC_mismatch, Metastability, Off_set, Output_compat, PEX_Basic_op, PEX_Decision_delay, PEX_Kickback, PEX_Off_set, PEX_Power_energy, Power_energy, Reset_op, Trim_a, Trim_b
  fs_v1p8_t125: temperature=125; vcc=1.8; sky130.lib.spice[fs]; not for Basic_op, Clk_duty, Clk_edge, Clk_freq, Clk_reset, Common_mode, Decision_delay, History_dep, Input_ref_noise, Kickback, MC_mismatch, Metastability, Off_set, Output_compat, PEX_Basic_op, PEX_Decision_delay, PEX_Kickback, PEX_Off_set, PEX_Power_energy, Power_energy, Reset_op, Trim_a, Trim_b
  fs_v1p98_tm40: temperature=-40; vcc=1.98; sky130.lib.spice[fs]; not for Basic_op, Clk_duty, Clk_edge, Clk_freq, Clk_reset, Common_mode, Decision_delay, History_dep, Input_ref_noise, Kickback, MC_mismatch, Metastability, Off_set, Output_compat, PEX_Basic_op, PEX_Decision_delay, PEX_Kickback, PEX_Off_set, PEX_Power_energy, Power_energy, Reset_op, Trim_a, Trim_b
  fs_v1p98_t27: temperature=27; vcc=1.98; sky130.lib.spice[fs]; not for Basic_op, Clk_duty, Clk_edge, Clk_freq, Clk_reset, Common_mode, Decision_delay, History_dep, Input_ref_noise, Kickback, MC_mismatch, Metastability, Off_set, Output_compat, PEX_Basic_op, PEX_Decision_delay, PEX_Kickback, PEX_Off_set, PEX_Power_energy, Power_energy, Reset_op, Trim_a, Trim_b
  fs_v1p98_t125: temperature=125; vcc=1.98; sky130.lib.spice[fs]; not for Basic_op, Clk_duty, Clk_edge, Clk_freq, Clk_reset, Common_mode, Decision_delay, History_dep, Input_ref_noise, Kickback, MC_mismatch, Metastability, Off_set, Output_compat, PEX_Basic_op, PEX_Decision_delay, PEX_Kickback, PEX_Off_set, PEX_Power_energy, Power_energy, Reset_op, Trim_a, Trim_b
Specs:
  Basic_op / dec_pos: > 0.5
  Basic_op / dec_neg: < -0.5
  Basic_op / n_wrong: < 1
  Basic_op / n_unres: < 1
  Reset_op / outp_rst: > 0.95
  Reset_op / outn_rst: > 0.95
  Reset_op / net2_rst: > 0.9
  Reset_op / net3_rst: > 0.9
  Reset_op / t_reset_frac: < 0.5
  Off_set / Vos: range -5m to 5m
  Input_ref_noise / sigma_n: < 1.75m
  Decision_delay / t_cq_frac: < 1
  Metastability / n_unres: < 1
  Common_mode / Vos: range -5m to 5m
  Common_mode / n_unres: < 1
  Kickback / kick_diff: < 3.5m
  History_dep / dVth_hist: range -1m to 1m
  Clk_freq / n_wrong: < 1
  Clk_freq / n_unres: < 1
  Clk_edge / n_wrong: < 1
  Clk_edge / n_unres: < 1
  Clk_duty / n_wrong: < 1
  Clk_duty / n_unres: < 1
  Clk_reset / n_wrong: < 1
  Clk_reset / n_unres: < 1
  Output_compat / V_high: > 0.9
  Output_compat / V_low: < 0.1
  Output_compat / V_peak: < 1.1
  Output_compat / V_undershoot: > -0.1
  Output_compat / setup_margin: > 0
  Output_compat / n_unres: < 1
  PVT / Vos: range -5m to 5m
  PVT / n_unres: < 1
  PEX_Basic_op / dec_pos: > 0.5
  PEX_Basic_op / dec_neg: < -0.5
  PEX_Basic_op / n_wrong: < 1
  PEX_Basic_op / n_unres: < 1
  PEX_Off_set / Vos: range -5m to 5m
  PEX_Decision_delay / t_cq_frac: < 1
  PEX_Kickback / kick_diff: < 3.5m
