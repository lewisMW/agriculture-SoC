ADE simulation setup
Run mode: Single Run, Sweeps and Corners
Tests:
  carray_8b_t1: sar_adc/tb_carray_8b/auto_config, simulator ams
    Variables: cap_unit = 34.6223; Vsupply = 1.8
    Outputs: /pass_flag; /vtop; /vbottom<7>; /vbottom<7:0>; /pass_counter<7:0>
