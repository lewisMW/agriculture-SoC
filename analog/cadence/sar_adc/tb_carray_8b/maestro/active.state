ADE simulation setup
Test adc_tb_lib_tb_cap_array_1: adc_tb_lib/tb_cap_array/auto_config, simulator ams
  Models: /home/hee/cadence/lib/sky130_release_0.1.0/models/sky130.lib.spice[tt]
  Variables: cap_unit = 34.6223; Vsupply = 1.8
  Temperature: 27
  Stimulus vcc!: voltage dc dc=Vsupply srcType=dc
  Analysis tran: stop=33u
  Signals: /pass_flag, /vtop, /vbottom<7:0>, /pass_counter<7:0>
Test carray_8b_t1: sar_adc/tb_carray_8b/auto_config, simulator ams
  Models: /opt/pdk/sky130_release_0.1.0/models/sky130.lib.spice[tt]
  Variables: cap_unit = 34.6223; Vsupply = 1.8
  Temperature: 27
  Stimulus vcc!: voltage dc dc=Vsupply srcType=dc
  Analysis tran: stop=33u
  Signals: /pass_flag, /vtop, /vbottom<7:0>, /pass_counter<7:0>
