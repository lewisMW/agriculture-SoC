ADE simulation setup
Test adc_tb_lib_tb_capacitor_1: adc_tb_lib/tb_capacitor/config, simulator ams
  Temperature: 27
  Analysis ac: start=0.1 stop=10M
  Analysis tran: stop=6u
  Signals: /DUT/top (terminal), /DUT/top
Test sar_adc_tb_capacitor_1: sar_adc/tb_capacitor/config, simulator ams
  Models: /opt/pdk/sky130_release_0.1.0/models/sky130.lib.spice[tt]
  Variables: load = 10
  Temperature: 27
  Stimulus vin: voltage pulse val0=0 val1=1.8 delay=10.0p rise=10p srcType=pulse
  Stimulus vssa: voltage dc dc=0 srcType=dc
  Analysis tran: stop=30p
  Signals: /Vout, /vin
Run mode: Single Run, Sweeps and Corners
