ADE simulation setup
Test SoC_Comparator_1: SoC/Comparator/schematic, simulator spectre
  Models: /home/admin/Documents/PDKs/sky130_release_0.1.0/libs/sky130_fd_pr_main/../../models/sky130.lib.spice[tt]
  Temperature: 27
