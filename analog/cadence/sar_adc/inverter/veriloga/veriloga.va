// VerilogA for SoC_probe, inverter, veriloga

`include "constants.vams"
`include "disciplines.vams"

module inverter(out, in, vdd, vss);
input in;
output out;
inout vdd ,vss;
electrical in, out, vdd, vss;

integer d_in;

analog begin
	@(cross(V(in,vss) - 0.5*V(vdd,vss)))
		;
	d_in = V(in,vss) > 0.5*V(vdd,vss);

	V(out,vss) <+ V(vdd,vss)*transition(!d_in, 0, 10n);
end
endmodule
