ADE simulation setup
Run mode: Single Run, Sweeps and Corners
Tests:
  adc_tb_lib_tb_comparator_1: adc_tb_lib/tb_comparator/auto_config, simulator ams
    Variables: VCC = 1.8; fs = 800e3; offset_p = 0; offset_n = 0; f_in = 40k; vcm = 1/VCC; a_in = 0.2
    Outputs: /outp; /outn; /inp; /inn; /clk
  adc_tb_lib_tb_comparator_1_1: adc_tb_lib/tb_comparator/auto_config, simulator ams
    Variables: VCC = 1.8; fs = 800e3; offset_p = 16; offset_n = 0; f_in = 40k; vcm = 1/VCC; a_in = 0.2
    Outputs: /outp; /outn; /inp; /inn; /clk; /trima<4:0>; /trimb<4:0>
