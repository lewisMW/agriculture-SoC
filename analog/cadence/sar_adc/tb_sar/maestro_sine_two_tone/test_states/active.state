ADE simulation setup
Test sar_adc_sine_two_tone: sar_adc/tb_sar/config, simulator spectre
  Output fft_vout = dft(VT("/vout") VAR("t0") VAR("t1") VAR("Nfft") "Rectangular" 1 "default" 1.0)
  Output f2_vout = abs(value(fft_vout VAR("fin_2")))
  Output f1_vout = abs(value(fft_vout VAR("fin_1")))
  Output f_diff_vout = real(value(fft_vout (f2_vout - f1_vout)))
  Output f_sum_vout = real(value(fft_vout (f2_vout + f1_vout)))
  Output IMD_vout = (10 * log10((((rms(f_diff_vout)**2) + (rms(f_sum_vout)**2)) / ((rms(VT("/vp"))**2) + rms(VT("/vn"))))))
  Output codes = ((VT("/result<0>") + (2 * VT("/result<1>")) + (4 * VT("/result<2>")) + (8 * VT("/result<3>")) + (16 * VT("/result<4>")) + (32 * VT("/result<5>")) + (64 * VT("/result<6>")) + (128 * VT("/result<7>"))) / 1.8)
  Output vin = (VT("/vp") - VT("/vn"))
  Output fft_vin = dft(vin VAR("t0") VAR("t1") VAR("Nfft") "Rectangular" 1 "default" 1.0) (unticked)
  Output sfdr_codes = spectrumMeasurement(codes t VAR("t0") VAR("t1") VAR("Nfft") 0 50000 0 "Rectangular" 0 0 2 "sfdr")
  Output fft_codes = dft(codes VAR("t0") VAR("t1") VAR("Nfft") "Rectangular" 1 "default" 1.0)
  Output sfdr_vout = spectrumMeasurement(VT("/vout") t VAR("t0") VAR("t1") VAR("Nfft") 0 50000 0 "Rectangular" 0 0 2 "sfdr")
  Signals: /vp, /vn, /result<7:0>, /valid, /clk, /en, /rstn, /cal, /vout
