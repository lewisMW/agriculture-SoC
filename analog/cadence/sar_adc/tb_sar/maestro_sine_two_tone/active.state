ADE simulation setup
Test sar_adc_sine_two_tone: sar_adc/tb_sar/config, simulator spectre
  Output fft_vout = dft(VT("/vout") VAR("t0") VAR("t1") VAR("Nfft") "Rectangular" 1 "default" 1.0)
  Output f2_vout = abs(value(fft_vout VAR("fin_2")))
  Output f1_vout = abs(value(fft_vout VAR("fin_1")))
  Output f_diff_vout = real(value(fft_vout (f2_vout - f1_vout)))
  Output f_sum_vout = real(value(fft_vout (f2_vout + f1_vout)))
  Output IMD_vout = (10 * log10((((rms(f_diff_vout)**2) + (rms(f_sum_vout)**2)) / ((rms(VT("/vp"))**2) + rms(VT("/vn"))))))
  Output codes = ((VT("/result<0>") + (2 * VT("/result<1>")) + (4 * VT("/result<2>")) + (8 * VT("/result<3>")) + (16 * VT("/result<4>")) + (32 * VT("/result<5>")) + (64 * VT("/result<6>")) + (128 * VT("/result<7>"))) / 1.8)
  Output vin = (VT("/vp") - VT("/vn"))
  Output fft_vin = dft(vin VAR("t0") VAR("t1") VAR("Nfft") "Rectangular" 1 "default" 1.0) (unticked)
  Output sfdr_codes = spectrumMeasurement(codes t VAR("t0") VAR("t1") VAR("Nfft") 0 50000 0 "Rectangular" 0 0 2 "sfdr")
  Output fft_codes = dft(codes VAR("t0") VAR("t1") VAR("Nfft") "Rectangular" 1 "default" 1.0)
  Output sfdr_vout = spectrumMeasurement(VT("/vout") t VAR("t0") VAR("t1") VAR("Nfft") 0 50000 0 "Rectangular" 0 0 2 "sfdr")
  Signals: /vp, /vn, /result<7:0>, /valid, /clk, /en, /rstn, /cal, /vout
Run mode: Single Run, Sweeps and Corners
Setup values for test sar_adc_sine_two_tone: fclk = 1000000; Nfft = 1024; M_cycles_1 = 59; M_cycles_2 = 67; N_drop = 2; t_start = 0.0001005; vssa = 0; vdda = 1.8; v_cm = 0.9; fs = fclk/10; v_ref = vdda; fin_1 = fs*M_cycles_1/Nfft; fin_2 = fs*M_cycles_2/Nfft; t_drop = N_drop/fs; t0 = t_start + t_drop; t1 = t0 + M_cycles_2/fin_2; t_sim = t_start + t_drop + (t1-t0) + 1/fs
