design( "sar_adc" "tb_sar" "config")
modelFile(
    '("/opt/pdk/sky130_release_0.1.0/libs/sky130_fd_pr_main/../../models/sky130.lib.spice" "tt")
)
analysis('tran ?stop "VAR(\"t_sim\")"  )
desVar(	  "v_cm" 0.9	)
desVar(	  "vdda" 1.8	)
desVar(	  "vssa" 0	)
desVar(	  "t_start" 0.0001005	)
desVar(	  "N_drop" 2	)
desVar(	  "M_cycles_2" 67	)
desVar(	  "M_cycles_1" 59	)
desVar(	  "Nfft" 1024	)
desVar(	  "fclk" 1000000	)
desVar(	  "v_ref" "vdda"	)
desVar(	  "fs" "fclk/10"	)
desVar(	  "t_drop" "N_drop/fs"	)
desVar(	  "fin_2" "fs*M_cycles_2/Nfft"	)
desVar(	  "fin_1" "fs*M_cycles_1/Nfft"	)
desVar(	  "t0" "t_start + t_drop"	)
desVar(	  "t1" "t0 + M_cycles_2/fin_2"	)
desVar(	  "t_sim" "t_start + t_drop + (t1-t0) + 1/fs"	)
envOption(
	'analysisOrder  list("pz" "dcmatch" "stb" "tran" "envlp" "ac" "dc" "lf" "noise" "xf" "sp" "pss" "pac" "pstb" "pnoise" "pxf" "psp" "qpss" "qpac" "qpnoise" "qpxf" "qpsp" "hb" "hbac" "hbstb" "hbnoise" "hbxf" "sens" "acmatch" "ofa")
)
option(	'pzSeverity  "None"
	'noiseSeverity  "None"
	'spSeverity  "None"
	'acSeverity  "None"
	'dcOpSeverity  "None"
	'dcSeverity  "None"
	'tranSeverity  "None"
	'checklimitdest  "sqldb"
)
saveOption( ?infoOptions list(list("modelParameter" "models" "rawfile" "" "" "" t) list("element" "inst" "rawfile" "" "" "" t) list("outputParameter" "output" "rawfile" "" "" "" t) list("designParamVals" "parameters" "rawfile" "" "" "" t) list("primitives" "primitives" "rawfile" "" "" "" t) list("subckts" "subckts" "rawfile" "" "" "" t) list("asserts" "assert" "rawfile" "" "" "" nil) list("extremeinfo" "all" "logfile" "" "yes" "" nil) list("allcap" "allcap" "file" "" "" "" nil) list("simStatistics" "simstat" "rawfile" "" "" "" nil) list("<Click_To_Add>" "none" "rawfile" "" "" "" nil) ) )
save( 'v "/vp" "/vn" "/result<7:0>" "/valid" "/clk" "/en" "/rstn" "/cal" )
temp( 27 )
