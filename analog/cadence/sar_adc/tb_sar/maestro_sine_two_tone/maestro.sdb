ADE simulation setup
Run mode: Single Run, Sweeps and Corners
Tests:
  sar_adc_sine_two_tone: sar_adc/tb_sar/config, simulator spectre
    Variables: fclk = 1000000; Nfft = 1024; M_cycles_1 = 59; M_cycles_2 = 67; N_drop = 2; t_start = 0.0001005; vssa = 0; vdda = 1.8; v_cm = 0.9; fs = fclk/10; v_ref = vdda; fin_1 = fs*M_cycles_1/Nfft; fin_2 = fs*M_cycles_2/Nfft; t_drop = N_drop/fs; t0 = t_start + t_drop; t1 = t0 + M_cycles_2/fin_2; t_sim = t_start + t_drop + (t1-t0) + 1/fs
