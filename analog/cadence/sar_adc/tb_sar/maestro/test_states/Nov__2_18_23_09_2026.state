ADE simulation setup
Test sar_adc_sine_fft: sar_adc/tb_sar/config, simulator spectre
  Output codes = ((VT("/result<0>") + (2 * VT("/result<1>")) + (4 * VT("/result<2>")) + (8 * VT("/result<3>")) + (16 * VT("/result<4>")) + (32 * VT("/result<5>")) + (64 * VT("/result<6>")) + (128 * VT("/result<7>"))) / 1.8)
  Output enob = spectrumMeasurement(codes t VAR("t0") VAR("t1") VAR("Nfft") 0 50000 0 "Rectangular" 0 0 2 "enob")
  Output sfdr = spectrumMeasurement(codes t VAR("t0") VAR("t1") VAR("Nfft") 0 50000 0 "Rectangular" 0 0 2 "sfdr")
  Output sinad_codes = spectrumMeasurement(codes t VAR("t0") VAR("t1") VAR("Nfft") 0 50000.0 0 "Rectangular" 0 0 2 "sinad")
  Output vin = (VT("/vp") - VT("/vn"))
  Output sigpower = spectrumMeasurement(codes t VAR("t0") VAR("t1") VAR("Nfft") 0 50000 0 "Rectangular" 0 0 2 "sigpower")
  Output snr = spectrumMeasurement(codes t VAR("t0") VAR("t1") VAR("Nfft") 0 50000 0 "Rectangular" 0 0 2 "snr")
  Output fft_vin = dft(vin VAR("t0") VAR("t1") VAR("Nfft") "Rectangular" 1 "default" 1.0) (unticked)
  Output thd = spectrumMeasurement(codes t VAR("t0") VAR("t1") VAR("Nfft") 0 50000 0 "Rectangular" 0 0 5 "thd")
  Output fft_codes = dft(codes VAR("t0") VAR("t1") VAR("Nfft") "Rectangular" 1 "default" 1.0)
  Output sinad_vout = spectrumMeasurement(VT("/vout") t VAR("t0") VAR("t1") VAR("Nfft") 0 50000.0 0 "Rectangular" 0 0 2 "sinad")
  Output fft_vout = dft(VT("/vout") VAR("t0") VAR("t1") VAR("Nfft") "Rectangular" 1 "default" 1.0)
  Signals: /vp, /vn, /result<7:0>, /valid, /clk, /en, /rstn, /cal, /vout
