ADE simulation setup
Test sar_adc_sine_fft: sar_adc/tb_sar/config, simulator ams
  Output codes = ((VT("/result<0>") + (2 * VT("/result<1>")) + (4 * VT("/result<2>")) + (8 * VT("/result<3>")) + (16 * VT("/result<4>")) + (32 * VT("/result<5>")) + (64 * VT("/result<6>")) + (128 * VT("/result<7>"))) / 1.8)
  Output enob = spectrumMeasurement(codes t VAR("t0") VAR("t1") VAR("Nfft") 0 50000 0 "Rectangular" 0 0 2 "enob")
  Output sfdr = spectrumMeasurement(codes t VAR("t0") VAR("t1") VAR("Nfft") 0 50000 0 "Rectangular" 0 0 2 "sfdr")
  Output sinad_codes = spectrumMeasurement(codes t VAR("t0") VAR("t1") VAR("Nfft") 0 50000.0 0 "Rectangular" 0 0 2 "sinad")
  Output vin = (VT("/vp") - VT("/vn"))
  Output sigpower = spectrumMeasurement(codes t VAR("t0") VAR("t1") VAR("Nfft") 0 50000 0 "Rectangular" 0 0 2 "sigpower")
  Output snr = spectrumMeasurement(codes t VAR("t0") VAR("t1") VAR("Nfft") 0 50000 0 "Rectangular" 0 0 2 "snr")
  Output fft_vin = dft(vin VAR("t0") VAR("t1") VAR("Nfft") "Rectangular" 1 "default" 1.0) (unticked)
  Output thd = spectrumMeasurement(codes t VAR("t0") VAR("t1") VAR("Nfft") 0 50000 0 "Rectangular" 0 0 5 "thd")
  Output fft_codes = dft(codes VAR("t0") VAR("t1") VAR("Nfft") "Rectangular" 1 "default" 1.0)
  Output sinad_vout = spectrumMeasurement(VT("/vout") t VAR("t0") VAR("t1") VAR("Nfft") 0 50000.0 0 "Rectangular" 0 0 2 "sinad")
  Output fft_vout = dft(VT("/vout") VAR("t0") VAR("t1") VAR("Nfft") "Rectangular" 1 "default" 1.0)
  Signals: /vp, /vn, /result<7:0>, /valid, /clk, /en, /rstn, /cal, /vout
Run mode: Single Run, Sweeps and Corners
Setup values for test sar_adc_sine_fft: fclk = 1000000; Nfft = 1024; M_cycles = 31, 509; N_drop = 2; t_start = 0.0001005; vssa = 0; vdda = 1.8; v_cm = 0.9; fin_2 = 0; fs = fclk/10; v_ref = vdda; fin_1 = fs*M_cycles/Nfft; t_drop = N_drop/fs; t0 = t_start + t_drop; t1 = t0 + M_cycles/fin_1; t_sim = t_start + t_drop + (t1-t0) + 1/fs
