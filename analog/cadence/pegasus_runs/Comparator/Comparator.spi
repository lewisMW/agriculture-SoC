* +++++++++++++++++++++++++++++++++++++++++++++++++++++++++ *
* CDL Netlist:                                              *
*                                                           *
* Cell Name  : Comparator                                   *
* Netlisted  : Fri Oct  9 11:42:07 2026                     *
* Pegasus Version: 23.26-s005 Thu Oct 17 16:37:42 PDT 2024  *
* +++++++++++++++++++++++++++++++++++++++++++++++++++++++++ *
*.LDD
*.DEVTMPLT 0 R(res_generic_m1) met1_res met1(P) met1(N)
*.DEVTMPLT 1 R(res_generic_m2) met2_res met2(P) met2(N)
*.DEVTMPLT 2 R(res_generic_m3) met3_res met3(P) met3(N)
*.DEVTMPLT 3 R(res_generic_m4) met4_res met4(P) met4(N)
*.DEVTMPLT 4 R(res_generic_m5) met5_res met5(P) met5(N)
*.DEVTMPLT 5 D(diode_pd2nw_05v5) diode_pd2nw_05v5_rec psd(PLUS) nwell(MINUS)
*.DEVTMPLT 6 D(diode_pd2nw_05v5_hvt) diode_pd2nw_05v5_hvt_rec psd(PLUS) nwell(MINUS)
*.DEVTMPLT 7 D(diode_pd2nw_05v5_lvt) diode_pd2nw_05v5_lvt_rec psd(PLUS) nwell(MINUS)
*.DEVTMPLT 8 D(diode_pd2nw_11v0) diode_pd2nw_11v0_rec psd(PLUS) nwell(MINUS)
*.DEVTMPLT 9 D(diode_pw2nd_05v5) diode_pw2nd_05v5_rec pwell_all(PLUS) nsd(MINUS)
*.DEVTMPLT 10 D(diode_pw2nd_05v5_lvt) diode_pw2nd_05v5_lvt_rec pwell_all(PLUS) nsd(MINUS)
*.DEVTMPLT 11 D(diode_pw2nd_05v5_nvt) diode_pw2nd_05v5_nvt_rec pwell_all(PLUS) nsd(MINUS)
*.DEVTMPLT 12 D(diode_pw2nd_11v0) diode_pw2nd_11v0_rec pwell_all(PLUS) nsd(MINUS)
*.DEVTMPLT 13 R(RES_GENERIC_ND) diff_res np_term(P) np_term(N)
*.DEVTMPLT 14 R(RES_GENERIC_PD) diff_res pp_term(P) pp_term(N)
*.DEVTMPLT 15 MN(nfet_01v8) nfet_01v8_rec nSourceDrain(D) nfet(G) nSourceDrain(S) pwell_all(B)
*.DEVTMPLT 16 MP(pfet_01v8) pfet_01v8_rec pSourceDrain(D) pfet(G) pSourceDrain(S) nwell(B)
*.DEVTMPLT 17 MP(pfet_01v8_lvt) lvtpfet_01v8_rec pSourceDrain(D) lvtpfet(G) pSourceDrain(S) nwell(B)
*.DEVTMPLT 18 MN(nfet_01v8_lvt) lvtnfet_01v8_rec nSourceDrain(D) lvtnfet(G) nSourceDrain(S) pwell_all(B)
*.DEVTMPLT 19 MP(pfet_01v8_hvt) hvtpfet_01v8_rec pSourceDrain(D) hvtpfet(G) pSourceDrain(S) nwell(B)
*.DEVTMPLT 20 MN(nfet_03v3_nvt) HV_ngate_3v3 HV_source_drain(D) HV_FET_gate(G) HV_source_drain(S) pwell_all(B)
*.DEVTMPLT 21 MN(nfet_05v0_nvt) HV_ngate_5v0 HV_source_drain(D) HV_FET_gate(G) HV_source_drain(S) pwell_all(B)
*.DEVTMPLT 22 MN(nfet_g5v0d10v5) HV_ngate_5v10v HV_source_drain(D) HV_FET_gate(G) HV_source_drain(S) pwell_all(B)
*.DEVTMPLT 23 MP(pfet_g5v0d10v5) HV_pgate_5v10v HV_source_drain(D) HV_FET_gate(G) HV_source_drain(S) nwell(B)
*.DEVTMPLT 24 MN(nfet_20v0) nfet_v20_rec nfet_v20_drain(D) nfet_v20_gate(G) nfet_v20_source(S) pwell_all(B)
*.DEVTMPLT 25 MN(nfet_20v0_zvt) nfet_v20_zvt_rec nfet_v20_drain(D) nfet_v20_gate(G) nfet_v20_source(S) pwell_all(B)
*.DEVTMPLT 26 MP(pfet_20v0) pfet_v20_rec pfet_v20_drain(D) pfet_v20_gate(G) pfet_v20_source(S) nwell(B)
*.DEVTMPLT 27 Q(npn_05v5) npn_rec npnC(C) npnB(B) npnE(E) pwell_all(BN)
*.DEVTMPLT 28 Q(npn_11v0) hvnpn_rec npnC(C) npnB(B) hvnpnE(E) pwell_all(BN)
*.DEVTMPLT 29 Q(pnp_05v5) pnp_rec pnpC(C) pnpB(B) pnpE(E) pwell_all(BN)
*.DEVTMPLT 30 R(res_high_po_0p35) res_high_po_0p35_rec prec_resistor_term(PLUS) prec_resistor_term(MINUS) pwell_all(B)
*.DEVTMPLT 31 R(res_high_po_0p69) res_high_po_0p69_rec prec_resistor_term(PLUS) prec_resistor_term(MINUS) pwell_all(B)
*.DEVTMPLT 32 R(res_high_po_1p41) res_high_po_1p41_rec prec_resistor_term(PLUS) prec_resistor_term(MINUS) pwell_all(B)
*.DEVTMPLT 33 R(res_high_po_2p85) res_high_po_2p85_rec prec_resistor_term(PLUS) prec_resistor_term(MINUS) pwell_all(B)
*.DEVTMPLT 34 R(res_high_po_5p73) res_high_po_5p73_rec prec_resistor_term(PLUS) prec_resistor_term(MINUS) pwell_all(B)
*.DEVTMPLT 35 R(res_xhigh_po_0p35) res_xhigh_po_0p35_rec prec_resistor_term(PLUS) prec_resistor_term(MINUS) pwell_all(B)
*.DEVTMPLT 36 R(res_xhigh_po_0p69) res_xhigh_po_0p69_rec prec_resistor_term(PLUS) prec_resistor_term(MINUS) pwell_all(B)
*.DEVTMPLT 37 R(res_xhigh_po_1p41) res_xhigh_po_1p41_rec prec_resistor_term(PLUS) prec_resistor_term(MINUS) pwell_all(B)
*.DEVTMPLT 38 R(res_xhigh_po_2p85) res_xhigh_po_2p85_rec prec_resistor_term(PLUS) prec_resistor_term(MINUS) pwell_all(B)
*.DEVTMPLT 39 R(res_xhigh_po_5p73) res_xhigh_po_5p73_rec prec_resistor_term(PLUS) prec_resistor_term(MINUS) pwell_all(B)
*.DEVTMPLT 40 C(cap_mim_m3__base) capacitor top_plate(PLUS) bottom_plate(MINUS)

* +++++++++++++++++++++++++++++++++++++++++++++++++++++++++ *
* Sub cell: nfet_01v8_CDNS_791506519741                     *
* +++++++++++++++++++++++++++++++++++++++++++++++++++++++++ *
.subckt nfet_01v8_CDNS_791506519741 1 2 3
** N=10 EP=3 FDC=1
M0 3 1 2 2 nfet_01v8 L=3e-07 W=1e-06 $X=0 $Y=0 $dt=15
.ends nfet_01v8_CDNS_791506519741

* +++++++++++++++++++++++++++++++++++++++++++++++++++++++++ *
* Sub cell: nfet_01v8_CDNS_791506519742                     *
* +++++++++++++++++++++++++++++++++++++++++++++++++++++++++ *
.subckt nfet_01v8_CDNS_791506519742 1 2 3
** N=47 EP=3 FDC=8
M0 3 1 2 2 nfet_01v8 L=3e-07 W=1e-06 $X=0 $Y=0 $dt=15
M1 2 1 3 2 nfet_01v8 L=3e-07 W=1e-06 $X=580 $Y=0 $dt=15
M2 3 1 2 2 nfet_01v8 L=3e-07 W=1e-06 $X=1160 $Y=0 $dt=15
M3 2 1 3 2 nfet_01v8 L=3e-07 W=1e-06 $X=1740 $Y=0 $dt=15
M4 3 1 2 2 nfet_01v8 L=3e-07 W=1e-06 $X=2320 $Y=0 $dt=15
M5 2 1 3 2 nfet_01v8 L=3e-07 W=1e-06 $X=2900 $Y=0 $dt=15
M6 3 1 2 2 nfet_01v8 L=3e-07 W=1e-06 $X=3480 $Y=0 $dt=15
M7 2 1 3 2 nfet_01v8 L=3e-07 W=1e-06 $X=4060 $Y=0 $dt=15
.ends nfet_01v8_CDNS_791506519742

* +++++++++++++++++++++++++++++++++++++++++++++++++++++++++ *
* Sub cell: nfet_01v8_CDNS_791506519743                     *
* +++++++++++++++++++++++++++++++++++++++++++++++++++++++++ *
.subckt nfet_01v8_CDNS_791506519743 1 2 3
** N=14 EP=3 FDC=2
M0 3 1 2 2 nfet_01v8 L=3e-07 W=1e-06 $X=0 $Y=0 $dt=15
M1 2 1 3 2 nfet_01v8 L=3e-07 W=1e-06 $X=580 $Y=0 $dt=15
.ends nfet_01v8_CDNS_791506519743

* +++++++++++++++++++++++++++++++++++++++++++++++++++++++++ *
* Sub cell: nfet_01v8_CDNS_791506519744                     *
* +++++++++++++++++++++++++++++++++++++++++++++++++++++++++ *
.subckt nfet_01v8_CDNS_791506519744 1 2 3
** N=26 EP=3 FDC=4
M0 3 1 2 2 nfet_01v8 L=3e-07 W=1e-06 $X=0 $Y=0 $dt=15
M1 2 1 3 2 nfet_01v8 L=3e-07 W=1e-06 $X=580 $Y=0 $dt=15
M2 3 1 2 2 nfet_01v8 L=3e-07 W=1e-06 $X=1160 $Y=0 $dt=15
M3 2 1 3 2 nfet_01v8 L=3e-07 W=1e-06 $X=1740 $Y=0 $dt=15
.ends nfet_01v8_CDNS_791506519744

* +++++++++++++++++++++++++++++++++++++++++++++++++++++++++ *
* Sub cell: sarcta__C0                                      *
* +++++++++++++++++++++++++++++++++++++++++++++++++++++++++ *
.subckt sarcta__C0 cp cn
** N=2 EP=2 FDC=0
.ends sarcta__C0

* +++++++++++++++++++++++++++++++++++++++++++++++++++++++++ *
* Sub cell: MASCO__A1                                       *
* +++++++++++++++++++++++++++++++++++++++++++++++++++++++++ *
.subckt MASCO__A1 1 2 3
** N=3 EP=3 FDC=0
X0 1 2 sarcta__C0 $T=0 315 0 0 $X=0 $Y=0
X1 1 3 sarcta__C0 $T=560 315 0 0 $X=560 $Y=0
.ends MASCO__A1

* +++++++++++++++++++++++++++++++++++++++++++++++++++++++++ *
* Sub cell: sarct__trim_array                               *
* +++++++++++++++++++++++++++++++++++++++++++++++++++++++++ *
.subckt sarct__trim_array 1 2 3 4 5 6 7
** N=7 EP=7 FDC=0
X0 1 3 2 MASCO__A1 $T=0 -200 0 0 $X=0 $Y=-200
X1 1 5 2 MASCO__A1 $T=1120 -200 0 0 $X=1120 $Y=-200
X2 1 4 2 MASCO__A1 $T=2240 -200 0 0 $X=2240 $Y=-200
X3 1 5 2 MASCO__A1 $T=3360 -200 0 0 $X=3360 $Y=-200
X4 1 7 6 MASCO__A1 $T=4480 -200 0 0 $X=4480 $Y=-200
X5 1 2 5 MASCO__A1 $T=5600 -200 0 0 $X=5600 $Y=-200
X6 1 2 4 MASCO__A1 $T=6720 -200 0 0 $X=6720 $Y=-200
X7 1 2 5 MASCO__A1 $T=7840 -200 0 0 $X=7840 $Y=-200
X8 1 2 3 MASCO__A1 $T=8960 -200 0 0 $X=8960 $Y=-200
.ends sarct__trim_array

* +++++++++++++++++++++++++++++++++++++++++++++++++++++++++ *
* Sub cell: Trim                                            *
* +++++++++++++++++++++++++++++++++++++++++++++++++++++++++ *
.subckt Trim drain Vss d<3> d<2> d<0> d<1> d<4>
** N=12 EP=7 FDC=16
X49 d<0> Vss 11 nfet_01v8_CDNS_791506519741 $T=6185 2055 0 0 $X=5780 $Y=965
X50 d<1> Vss 12 nfet_01v8_CDNS_791506519741 $T=7675 2055 0 0 $X=7270 $Y=965
X51 d<4> Vss 8 nfet_01v8_CDNS_791506519742 $T=9165 2055 0 0 $X=8760 $Y=965
X52 d<2> Vss 10 nfet_01v8_CDNS_791506519743 $T=4115 2055 0 0 $X=3710 $Y=965
X53 d<3> Vss 9 nfet_01v8_CDNS_791506519744 $T=885 2055 0 0 $X=480 $Y=965
X54 drain 8 Vss 10 9 12 11 sarct__trim_array $T=1705 7545 0 0 $X=1705 $Y=7345
.ends Trim

* +++++++++++++++++++++++++++++++++++++++++++++++++++++++++ *
* Sub cell: nfet_01v8_CDNS_791506519745                     *
* +++++++++++++++++++++++++++++++++++++++++++++++++++++++++ *
.subckt nfet_01v8_CDNS_791506519745 1 2 3
** N=11 EP=3 FDC=2
M0 3 1 2 2 nfet_01v8 L=3e-07 W=1e-06 $X=0 $Y=0 $dt=15
M1 2 1 3 2 nfet_01v8 L=3e-07 W=1e-06 $X=580 $Y=0 $dt=15
.ends nfet_01v8_CDNS_791506519745

* +++++++++++++++++++++++++++++++++++++++++++++++++++++++++ *
* Sub cell: nfet_01v8_CDNS_791506519746                     *
* +++++++++++++++++++++++++++++++++++++++++++++++++++++++++ *
.subckt nfet_01v8_CDNS_791506519746 1 2 3 4
** N=9 EP=4 FDC=1
M0 3 1 2 4 nfet_01v8 L=3e-07 W=1e-06 $X=0 $Y=0 $dt=15
.ends nfet_01v8_CDNS_791506519746

* +++++++++++++++++++++++++++++++++++++++++++++++++++++++++ *
* Sub cell: nfet_01v8_CDNS_791506519747                     *
* +++++++++++++++++++++++++++++++++++++++++++++++++++++++++ *
.subckt nfet_01v8_CDNS_791506519747 1 2 3 4
** N=9 EP=4 FDC=1
M0 3 1 2 4 nfet_01v8 L=3e-07 W=1e-06 $X=0 $Y=0 $dt=15
.ends nfet_01v8_CDNS_791506519747

* +++++++++++++++++++++++++++++++++++++++++++++++++++++++++ *
* Sub cell: pfet_01v8_CDNS_791506519748                     *
* +++++++++++++++++++++++++++++++++++++++++++++++++++++++++ *
.subckt pfet_01v8_CDNS_791506519748 1 2 3
** N=11 EP=3 FDC=1
M0 3 1 2 2 pfet_01v8 L=3e-07 W=1e-06 $X=0 $Y=0 $dt=16
.ends pfet_01v8_CDNS_791506519748

* +++++++++++++++++++++++++++++++++++++++++++++++++++++++++ *
* Sub cell: Comparator                                      *
* +++++++++++++++++++++++++++++++++++++++++++++++++++++++++ *
.subckt Comparator Clk Out_N Out_P Trima<0> Trima<1> Trima<2> Trima<3> Trima<4> Trimb<0> Trimb<1>
+ Trimb<2> Trimb<3> Trimb<4> Vdd Vn Vp Vss
** N=20 EP=17 FDC=44
X34 1 Vss Trima<3> Trima<2> Trima<0> Trima<1> Trima<4> Trim $T=-12720 14805 0 270 $X=-12745 $Y=-275
X35 6 Vss Trimb<3> Trimb<2> Trimb<0> Trimb<1> Trimb<4> Trim $T=30475 14805 1 270 $X=18285 $Y=-275
X36 Clk Vss 20 nfet_01v8_CDNS_791506519745 $T=8470 1700 0 0 $X=8065 $Y=1190
X37 Vp 20 6 Vss nfet_01v8_CDNS_791506519746 $T=9315 4865 0 0 $X=8910 $Y=4715
X38 Out_N 6 Out_P Vss nfet_01v8_CDNS_791506519746 $T=10425 4865 0 0 $X=10020 $Y=4715
X39 Out_P 1 Out_N Vss nfet_01v8_CDNS_791506519747 $T=7395 5865 0 180 $X=6690 $Y=4715
X40 Vn 20 1 Vss nfet_01v8_CDNS_791506519747 $T=8505 5865 0 180 $X=7800 $Y=4715
X41 Clk Vdd 1 pfet_01v8_CDNS_791506519748 $T=2495 12065 1 180 $X=1750 $Y=11555
X42 Clk Vdd Out_N pfet_01v8_CDNS_791506519748 $T=4905 12065 0 0 $X=3900 $Y=11555
X43 Out_P Vdd Out_N pfet_01v8_CDNS_791506519748 $T=7695 12065 1 180 $X=6950 $Y=11555
X44 Out_N Vdd Out_P pfet_01v8_CDNS_791506519748 $T=10105 12065 0 0 $X=9100 $Y=11555
X45 Clk Vdd Out_P pfet_01v8_CDNS_791506519748 $T=12895 12065 1 180 $X=12150 $Y=11555
X46 Clk Vdd 6 pfet_01v8_CDNS_791506519748 $T=15305 12065 0 0 $X=14300 $Y=11555
.ends Comparator
