***********************************************************
* CDL produced by pvsBuildNetlist on Sep 29 18:59:58 2026 *
***********************************************************

*pvsViewList = auLvs schematic
*pvsStopList = ("auLvs")
*pvsSimName  = auLvs

*.EXPAND_ON_M_FACTOR
*.MEGA

.subckt mim_cap_adc bottom top vssa
*PVSCELL netlisted from sar_adc mim_cap_adc schematic
  CC0 top bottom cap_mim_m3__base l=4u w=4u m=1
.ends mim_cap_adc

.subckt mim_cap_test bottom top vssa
*PVSCELL netlisted from sar_adc mim_cap_test schematic
  XC0 mim_cap_adc $PINS bottom=bottom top=top vssa=vssa
  XC1 mim_cap_adc $PINS bottom=bottom top=top vssa=vssa
.ends mim_cap_test

***********************************************************
*             Completed at Sep 29 18:59:58 2026           *
***********************************************************
