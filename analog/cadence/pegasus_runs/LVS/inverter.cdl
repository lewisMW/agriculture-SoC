************************************************************************
* auCdl Netlist:
*
* Library Name:  sar_adc
* Top Cell Name: inverter
* View Name:     schematic
* Netlisted on:  Aug 31 18:14:33 2026
************************************************************************

*.BIPOLAR
*.RESI = 2000
*.RESVAL
*.CAPVAL
*.DIOPERI
*.DIOAREA
*.EQUATION
*.SCALE METER
*.MEGA
.PARAM

************************************************************************
* Library Name: sar_adc
* Cell Name:    inverter
* View Name:    schematic
************************************************************************

.SUBCKT inverter in out vdd vss
*.PININFO in:I out:O vdd:B vss:B
.ENDS
