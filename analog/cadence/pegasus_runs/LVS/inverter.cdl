*****************************************************************************
* CDL Netlist:
* Cell Name: mim_cap_adc
* Netlisted on: Sep 26 09:50:31 2026
*****************************************************************************

*****************************************************************************
* BIPOLAR Declarations
*****************************************************************************
*.BIPOLAR
*.RESI = 2000.000000
*.RESVAL
*.CAPVAL
*.DIOPERI
*.DIOAREA
*.SCALE METER

*****************************************************************************
* Parameter Statement
*****************************************************************************
.PARAM

*******************************************************************************
* Main Circuit Netlist:                                                       *
*                                                                             *
* Library: sar_adc                                                            *
* Cell   : mim_cap_adc                                                        *
* View   : schematic                                                          *
* Last Time Saved: Sep 26 09:49:23 2026                                       *
*******************************************************************************
.subckt mim_cap_adc bottom top vssa
*.PININFO bottom:B top:B vssa:B
.ends mim_cap_adc
