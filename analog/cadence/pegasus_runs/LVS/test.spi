* +++++++++++++++++++++++++++++++++++++++++++++++++++++
* CDL Netlist:
*
* Cell Name: test
* Netlisted: 2026-08-31 17:26:03
* Pegasus 24.12-s023
* +++++++++++++++++++++++++++++++++++++++++++++++++++++
*.LDD
*.DEVTMPLT 0 MN(nfet_01v8) nfet_01v8_rec nSourceDrain(D) nfet(G) nSourceDrain(S) pwell_all(B)

* +++++++++++++++++++++++++++++++++++++++++++++++++++++
* Sub cell: test
* +++++++++++++++++++++++++++++++++++++++++++++++++++++
.subckt test
M0 4 3 5 6 nfet_01v8 L=1.5e-07 W=4.2e-07 $X=755 $Y=620 $dt=0
** N=6 EP=0 NDC=1 FDC=1 HDC=1
.ends test
