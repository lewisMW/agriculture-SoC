* +++++++++++++++++++++++++++++++++++++++++++++++++++++
* CDL Netlist:
*
* Cell Name: inverter
* Netlisted: 2026-08-31 18:15:02
* Pegasus 24.12-s023
* +++++++++++++++++++++++++++++++++++++++++++++++++++++
*.LDD
*.DEVTMPLT 0 MN(nfet_01v8) nfet_01v8_rec nSourceDrain(D) nfet(G) nSourceDrain(S) pwell_all(B)
*.DEVTMPLT 1 MP(pfet_01v8) pfet_01v8_rec pSourceDrain(D) pfet(G) pSourceDrain(S) nwell(B)

* +++++++++++++++++++++++++++++++++++++++++++++++++++++
* Sub cell: inverter
* +++++++++++++++++++++++++++++++++++++++++++++++++++++
.subckt inverter vss vdd out in
M0 vss in out vss nfet_01v8 L=1.5e-07 W=4.2e-07 $X=1245 $Y=1220 $dt=0
M1 vdd in out vdd pfet_01v8 L=1.5e-07 W=5.5e-07 $X=1245 $Y=2380 $dt=1
** N=11 EP=4 NDC=2 FDC=2 HDC=2
.ends inverter
