* +++++++++++++++++++++++++++++++++++++++++++++++++++++
* CDL Netlist:
*
* Cell Name: mim_cap_adc
* Netlisted: 2026-09-21 18:45:32
* Pegasus 24.12-s023
* +++++++++++++++++++++++++++++++++++++++++++++++++++++
*.LDD
*.DEVTMPLT 0 C(cap_mim_m3__base) capacitor top_plate(PLUS) bottom_plate(MINUS)

* +++++++++++++++++++++++++++++++++++++++++++++++++++++
* Sub cell: mim_cap_adc
* +++++++++++++++++++++++++++++++++++++++++++++++++++++
.subckt mim_cap_adc top bottom 3
C0 top bottom 0 $[cap_mim_m3__base] $X=0 $Y=0 $dt=0
** N=4 EP=3 NDC=1 FDC=1 HDC=1
.ends mim_cap_adc
