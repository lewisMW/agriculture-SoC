*******************************************************************
* CDL Produced by pegasusBuildNetlist on Mon Sep 21 18:35:06 2026 *
*******************************************************************

* File content...

***********************************************************
* CDL produced by pvsBuildNetlist on Sep 21 18:35:06 2026 *
***********************************************************

*pvsViewList = auLvs schematic
*pvsStopList = ("auLvs")
*pvsSimName  = auLvs

*.EXPAND_ON_M_FACTOR
*.MEGA

.subckt mim_cap_adc bottom top vssa
*PVSCELL netlisted from sar_adc mim_cap_adc schematic
  CC0 top bottom cap_mim_m3__base l=4u w=4u m=1
.ends mim_cap_adc

***********************************************************
*             Completed at Sep 21 18:35:06 2026           *
***********************************************************
