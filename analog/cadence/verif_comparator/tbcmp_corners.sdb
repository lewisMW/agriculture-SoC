ADE simulation setup
Corners:
  model folders: /home/admin/Documents/PDKs/sky130_release_0.1.0/models
  tt_v1p62_tm40: temperature=-40; vcc=1.62; sky130.lib.spice[tt]
  tt_v1p62_t27: temperature=27; vcc=1.62; sky130.lib.spice[tt]
  tt_v1p62_t125: temperature=125; vcc=1.62; sky130.lib.spice[tt]
  tt_v1p8_tm40: temperature=-40; vcc=1.8; sky130.lib.spice[tt]
  tt_v1p8_t27: temperature=27; vcc=1.8; sky130.lib.spice[tt]
  tt_v1p8_t125: temperature=125; vcc=1.8; sky130.lib.spice[tt]
  tt_v1p98_tm40: temperature=-40; vcc=1.98; sky130.lib.spice[tt]
  tt_v1p98_t27: temperature=27; vcc=1.98; sky130.lib.spice[tt]
  tt_v1p98_t125: temperature=125; vcc=1.98; sky130.lib.spice[tt]
  ff_v1p62_tm40: temperature=-40; vcc=1.62; sky130.lib.spice[ff]
  ff_v1p62_t27: temperature=27; vcc=1.62; sky130.lib.spice[ff]
  ff_v1p62_t125: temperature=125; vcc=1.62; sky130.lib.spice[ff]
  ff_v1p8_tm40: temperature=-40; vcc=1.8; sky130.lib.spice[ff]
  ff_v1p8_t27: temperature=27; vcc=1.8; sky130.lib.spice[ff]
  ff_v1p8_t125: temperature=125; vcc=1.8; sky130.lib.spice[ff]
  ff_v1p98_tm40: temperature=-40; vcc=1.98; sky130.lib.spice[ff]
  ff_v1p98_t27: temperature=27; vcc=1.98; sky130.lib.spice[ff]
  ff_v1p98_t125: temperature=125; vcc=1.98; sky130.lib.spice[ff]
  ss_v1p62_tm40: temperature=-40; vcc=1.62; sky130.lib.spice[ss]
  ss_v1p62_t27: temperature=27; vcc=1.62; sky130.lib.spice[ss]
  ss_v1p62_t125: temperature=125; vcc=1.62; sky130.lib.spice[ss]
  ss_v1p8_tm40: temperature=-40; vcc=1.8; sky130.lib.spice[ss]
  ss_v1p8_t27: temperature=27; vcc=1.8; sky130.lib.spice[ss]
  ss_v1p8_t125: temperature=125; vcc=1.8; sky130.lib.spice[ss]
  ss_v1p98_tm40: temperature=-40; vcc=1.98; sky130.lib.spice[ss]
  ss_v1p98_t27: temperature=27; vcc=1.98; sky130.lib.spice[ss]
  ss_v1p98_t125: temperature=125; vcc=1.98; sky130.lib.spice[ss]
  sf_v1p62_tm40: temperature=-40; vcc=1.62; sky130.lib.spice[sf]
  sf_v1p62_t27: temperature=27; vcc=1.62; sky130.lib.spice[sf]
  sf_v1p62_t125: temperature=125; vcc=1.62; sky130.lib.spice[sf]
  sf_v1p8_tm40: temperature=-40; vcc=1.8; sky130.lib.spice[sf]
  sf_v1p8_t27: temperature=27; vcc=1.8; sky130.lib.spice[sf]
  sf_v1p8_t125: temperature=125; vcc=1.8; sky130.lib.spice[sf]
  sf_v1p98_tm40: temperature=-40; vcc=1.98; sky130.lib.spice[sf]
  sf_v1p98_t27: temperature=27; vcc=1.98; sky130.lib.spice[sf]
  sf_v1p98_t125: temperature=125; vcc=1.98; sky130.lib.spice[sf]
  fs_v1p62_tm40: temperature=-40; vcc=1.62; sky130.lib.spice[fs]
  fs_v1p62_t27: temperature=27; vcc=1.62; sky130.lib.spice[fs]
  fs_v1p62_t125: temperature=125; vcc=1.62; sky130.lib.spice[fs]
  fs_v1p8_tm40: temperature=-40; vcc=1.8; sky130.lib.spice[fs]
  fs_v1p8_t27: temperature=27; vcc=1.8; sky130.lib.spice[fs]
  fs_v1p8_t125: temperature=125; vcc=1.8; sky130.lib.spice[fs]
  fs_v1p98_tm40: temperature=-40; vcc=1.98; sky130.lib.spice[fs]
  fs_v1p98_t27: temperature=27; vcc=1.98; sky130.lib.spice[fs]
  fs_v1p98_t125: temperature=125; vcc=1.98; sky130.lib.spice[fs]
