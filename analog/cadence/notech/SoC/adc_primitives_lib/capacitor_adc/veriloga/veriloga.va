//Verilog-AMS HDL for adc_primitives_lib, capacitor, veriloga

`include "constants.vams"
`include "disciplines.vams"

module capacitor_adc(top, bottom);
parameter real c=1e-15;

inout top, bottom;
electrical top, bottom;

analog begin
	I(top,bottom) <+ c*ddt(V(top,bottom));
end
endmodule
