ADE simulation setup
Run mode: Single Run, Sweeps and Corners
Tests:
  SoC_sample_Hold_1_1 (off): SoC/sample_Hold_1/config, simulator ams
    Variables: wireopt = 0
    Outputs: /net2; /gnd!; /Current; /I0/holdSig
  SoC_sample_Hold_1_2 (off): SoC/sample_Hold_1/config, simulator ams
    Variables: wireopt = 0
  SoC_sample_Hold_1_3 (off): SoC/sample_Hold_1/schematic, simulator spectre
    Variables: wireopt = nil
