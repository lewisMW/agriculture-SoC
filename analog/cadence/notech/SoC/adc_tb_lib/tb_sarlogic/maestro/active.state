ADE simulation setup
Test adc_tb_lib_tb_sarlogic_1: adc_tb_lib/tb_sarlogic/config, simulator ams
  Temperature: 27
  Analysis tran: stop=150u
  Signals: /clk, /DUT/clkc, /DUT/rstn, /DUT/en, /DUT/cal, /DUT/sample, /DUT/comp, /result<7:0>, /DUT/valid, /DUT/trima<4:0>, /DUT/trimb<4:0>, /DUT/ctlp<7:0>, /DUT/ctln<7:0>
Run mode: Single Run, Sweeps and Corners
