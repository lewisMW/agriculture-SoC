ADE simulation setup
Run mode: Single Run, Sweeps and Corners
Tests:
  adc_tb_lib_tb_sarlogic_1: adc_tb_lib/tb_sarlogic/config, simulator ams
    Outputs: "/result<7:0>"; /result<7:0>; /DUT/trima<4:0>; /DUT/trimb<4:0>; /DUT/ctlp<7:0>; /DUT/ctln<7:0>
