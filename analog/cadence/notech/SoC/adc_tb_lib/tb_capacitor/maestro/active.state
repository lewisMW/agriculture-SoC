ADE simulation setup
Test adc_tb_lib_tb_capacitor_1: adc_tb_lib/tb_capacitor/config, simulator ams
  Temperature: 27
  Analysis ac: start=0.1 stop=10M
  Analysis tran: stop=6u
  Signals: /DUT/top (terminal), /DUT/top
Run mode: Single Run, Sweeps and Corners
