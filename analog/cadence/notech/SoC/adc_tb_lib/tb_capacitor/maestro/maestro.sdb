ADE simulation setup
Run mode: Single Run, Sweeps and Corners
Tests:
  adc_tb_lib_tb_capacitor_1: adc_tb_lib/tb_capacitor/config, simulator ams
    Outputs: "/\\top"; "/top"; "/fsdlkfj"; /fsdlkfj; "/tb_capacitor/top"; "/tb_capacitor/"; /tb_capacitor/; "/tb_capacitor.top"; /tb_capacitor.top; "/"; /v_top; "/DUT"; /DUT; IT("/DUT"); IT("/DUT/top")
