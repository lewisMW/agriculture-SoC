//Verilog-AMS HDL for "adc_tb_lib", "tb_switch" "verilogams"

`include "constants.vams"
`include "disciplines.vams"

module tb_switch ( );
	electrical vin, vout, gnd;
	ground gnd;
	reg ctrl;

	// =================================================
	// Test 1
	// =================================================
	vsource #(.srcType("dc"),
			.vdc(1.0)) vs1 (vin, gnd);

	// switch #(.ron(1), .roff(1e+12)) sw1 (.p(vout), .n(vin), .ctrl(ctrl));

	capacitor_adc #(.c(1e-15)) c1 (.top(vin), .bottom(gnd));

	// Simulation
	initial begin

		ctrl = 1'b0;
		#10;
		ctrl = 1'b1;
		#10;
		ctrl = 1'b0;
		#1200;
	end
endmodule
