ADE simulation setup
Test adc_tb_lib_tb_switch_1: adc_tb_lib/tb_switch/auto_config, simulator ams
  Variables: Fin = 10e3; Fsample = 0.1e6; VCC = 1.8
  Temperature: 27
  Analysis tran: stop=0.1m
  Signals: /vin, /ctrl, /vout
Run mode: Single Run, Sweeps and Corners
Setup values for test adc_tb_lib_tb_switch_1: SAMPLE_TIME = 5m
