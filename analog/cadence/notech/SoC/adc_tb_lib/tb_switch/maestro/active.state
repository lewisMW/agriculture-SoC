ADE simulation setup
Test adc_tb_lib_tb_switch_1: adc_tb_lib/tb_switch/auto_config, simulator ams
  Variables: SAMPLE_TIME = 5m; VCC = 1.8
  Temperature: 27
  Analysis tran: stop=1
  Signals: /vin, /ctrl, /vout
Run mode: Single Run, Sweeps and Corners
