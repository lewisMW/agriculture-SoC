ADE simulation setup
Run mode: Single Run, Sweeps and Corners
Tests:
  adc_tb_lib_tb_switch_1: adc_tb_lib/tb_switch/auto_config, simulator ams
    Variables: VCC = 1.8; Fsample = 0.1e6; Fin = 10e3
    Outputs: /vin; /ctrl; /vout
