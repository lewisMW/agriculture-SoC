//Verilog-AMS HDL for "adc_tb_lib", "tb_comparator" "verilogams"

`include "constants.vams"
`include "disciplines.vams"

module tb_comparator ( );

	// Parameters
	parameter real VDD = 1.8;
	parameter real VCM = VDD/2.0;		// nominal common mode
	parameter real VDIFF_MAX = 0.2	// max differential swing (v)
	parameter real [4:0] CAL_A = 4'b0000;
	parameter real [4:0] CAL_B = 4'b0000;

	parameter real TSTEP = 10n;		// clock half-period
	parameter real TSETTLE = 100n;	// settle time after stimulus change
	parameter real TRAMP = 1n;		// stimulus voltage ramp time

	// Number of steps per sweep
	parameter real OFFSET_TOL = 5m;	// expected offset < 5mV (erase?)
	parameter real META_WIN = TSTEP;	// output must settle within one half-period
	parameter real CAL_RESIDUAL = 2m;	// residual after cal <2mV

	// Electrical nodes
	electrical vinp, vinn;
	electrical v_offset_cal;
	electrical vcm_node;
	electrical vdd, gnd;
	electrical voutp, voutn;

	// Digital signals
	reg clk;		// primary sample clock
	wire out_digital;	// sinle_ended output

	// Internal
	real vdiff_val;      // current programmed differential
	real vcal_val;       // current programmed cal voltage
	real vcm_val;        // current programmed vcm
	real t_rise;         // measured output rise time (metastability)
	real offset_meas;    // measured comparator offset
	real cal_residual;   // post-calibration residual offset
	integer pass_count, fail_count;

	// Supply sources
	vsource #(.dc(VDD)) isrc_vdd (.p(vdd), .n(gnd));

	// Stimulus voltage sources
	vsource #(.dc(0)) vsrc_vp (.p(vinp), .n(gnd));
	vsource #(.dc(0)) vsrc_vn (.p(vinn), .n(gnd));
	vsource #(.dc(0)) vsrc_cal (.p(v_offset_cal), .n(gnd));
	vsource #(.dc(VCM)) vsrc_vcm (.p(vcm_node), .n(gnd));

	// DUT
	comparator dut (.vp(vinp), .vn(vinn), .outp(voutp), .outn(voutn), .clk(clk),
			.trim(CAL_A), .trimb(CAL_B), .vdd(vdd), .vss(gnd));

	// Differential output resolved to digital
	real vout_diff_real;
	assign out_digital = vout_diff_real > 0.0 ? 1'b1 : 1'b0;

	analog begin
		vout_diff_real = V(voutp - voutn);
	end

	// Analog source control
	analog begin
		V(vinp) <+ transition(vcm_val + vdiff_val/2.0, 0, TRAMP, TRAMP);
		V(vinn) <+ transition(vcm_val - vdiff_val/2.0, 0, TRAMP, TRAMP);
		V(v_offset_cal) <+ transition(vcal_val, 0, TRAMP, TRAMP);
		V(vcm_node) <+ transition(vcm_val, 0, TRAMP, TRAMP);
	end

	// Clock
	initial clk = 1'b0;
	always #(TSTEP) clk = ~clk;

	// VCD dump
	initial

endmodule
