ADE simulation setup
Test adc_tb_lib_tb_comparator_1: adc_tb_lib/tb_comparator/auto_config, simulator ams
  Variables: offset_n = 0; offset_p = 0; fs = 800e3; VCC = 1.8; f_in = 40k; a_in = 0.2; vcm = 1/VCC
  Temperature: 27
  Stimulus vcc!: voltage dc dc=VCC srcType=dc
  Stimulus inp: voltage sin sinedc=vcm ampl=a_in freq=f_in filenums=none srcType=sine
  Stimulus inn: voltage dc dc=vcm srcType=dc
  Analysis tran: stop=30u
  Signals: /outp, /outn, /inp, /inn, /clk
Test adc_tb_lib_tb_comparator_1_1: adc_tb_lib/tb_comparator/auto_config, simulator ams
  Variables: offset_p = 16; offset_n = 0; fs = 800e3; VCC = 1.8; f_in = 40k; a_in = 0.2; vcm = 1/VCC
  Temperature: 27
  Stimulus vcc!: voltage dc dc=VCC srcType=dc
  Stimulus inp: voltage pwl offset=vcm pwlfilter=  abstime=  tvpairs=8 t1=0 v1=0 t2=5/fs v2=0 t3=6/fs v3=75.000m t4=15/fs v4=75.00m t5=16/fs v5=90.00m t6=25/fs v6=90.00m t7=26/fs v7=0 t8=35/fs v8=0 v9=0 v10=0 v11=0 v12=0 v13=0 v14=0 v15=0 v16=0 v17=0 v18=0 v19=0 v20=0 v21=0 v22=0 v23=0 v24=0 v25=0 v26=0 v27=0 v28=0 v29=0 v30=0 v31=0 v32=0 v33=0 v34=0 v35=0 v36=0 v37=0 v38=0 v39=0 v40=0 v41=0 v42=0 v43=0 v44=0 v45=0 v46=0 v47=0 v48=0 v49=0 v50=0 srcType=pwl
  Stimulus inn: voltage dc dc=vcm srcType=dc
  Analysis tran: stop=50u
  Signals: /outp, /outn, /inp, /inn, /clk, /trima<4:0>, /trimb<4:0>
Run mode: Single Run, Sweeps and Corners
