ADE simulation setup
Run mode: Single Run, Sweeps and Corners
Tests:
  adc_tb_lib_tb_cap_array_1: adc_tb_lib/tb_cap_array/auto_config, simulator ams
    Variables: cap_unit = 34.6223; Vsupply = 1.8
    Outputs: /pass_flag; /vtop; /vbottom<7>; /vbottom<7:0>; /pass_counter<7:0>
