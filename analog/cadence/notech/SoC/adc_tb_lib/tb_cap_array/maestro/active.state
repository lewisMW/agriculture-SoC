ADE simulation setup
Test adc_tb_lib_tb_cap_array_1: adc_tb_lib/tb_cap_array/auto_config, simulator ams
  Variables: cap_unit = 1f; Vsupply = 1.8
  Temperature: 27
  Stimulus vcc!: voltage dc dc=Vsupply srcType=dc
  Analysis tran: stop=33u
  Signals: /pass_flag, /vtop, /vbottom<7:0>, /pass_counter<7:0>
Run mode: Single Run, Sweeps and Corners
Setup values for test adc_tb_lib_tb_cap_array_1: cap_unit = 34.6223
