//Verilog-AMS HDL for "adc_analog_lib", "comparator" "verilogams"

`include "constants.vams"
`include "disciplines.vams"

module comparator(vp, vn, outp, outn, clk, trim, trimb, vdd, vss);
	input [4:0] trim, trimb;
	input clk, vn, vp;
	output outn, outp;
	inout vdd, vss ;
	electrical vp, vn, vdd, vss;
	logic [4:0] trim, trimb;
	logic clk;
	reg outp, outn;

	parameter real v_lsb = 5m;

	integer trim_code, trimb_code;
	real v_trim, v_trimb;
	integer d_out;

	genvar i;

	analog begin
		// Calibration by adding a v offset (what value? still don't know)
		trim_code  = (trim[0]? 1:0) + (trim[1]? 2:0) + (trim[2]? 4:0)
             + (trim[3]? 8:0) + (trim[4]?16:0);

  		trimb_code = (trimb[0]? 1:0) + (trimb[1]? 2:0) + (trimb[2]? 4:0)
             + (trimb[3]? 8:0) + (trimb[4]?16:0);

		v_trim = -trim_code*v_lsb + V(vp,vss);
		v_trimb = -trimb_code*v_lsb + V(vn,vss);

		// Comparision and differential output
		d_out = v_trim > v_trimb;
	end

	always @(posedge clk) begin
		if (d_out) begin outp <= d_out; outn <= !d_out; end
		else begin outp <= !d_out; outn <= d_out; end
	end
endmodule
