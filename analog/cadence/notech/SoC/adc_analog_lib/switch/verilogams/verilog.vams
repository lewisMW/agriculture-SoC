//Verilog-AMS HDL for "adc_analog_lib", "switch" "verilogams"

`include "constants.vams"
`include "disciplines.vams"

module switch ( p, n, ctrl );
	input ctrl;
	inout p, n;
	electrical p, n;
	logic ctrl;

	parameter real ron = 1;
	parameter real roff = 1e+12;

	analog begin
		if (ctrl)
      	I(p,n) <+ V(p,n)/ron; // on
    		else
      	I(p,n) <+ V(p,n)/roff; // off
	end
endmodule
