ADE simulation setup
Run mode: Single Run, Sweeps and Corners
Tests:
  Testench_Clock_test_1: Testench/Clock_test/config, simulator ams
