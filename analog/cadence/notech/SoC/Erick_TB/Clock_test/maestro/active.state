ADE simulation setup
Test Testench_Clock_test_1: Testench/Clock_test/config, simulator ams
  Temperature: 27
  Analysis tran: stop=0.01
  Signals: /pout, /I12/clk (terminal)
Run mode: Single Run, Sweeps and Corners
