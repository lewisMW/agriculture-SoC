ADE simulation setup
Run mode: Single Run, Sweeps and Corners
Tests:
  adc_analog_lib_Testbench_1: adc_analog_lib/Testbench/config, simulator ams
    Variables: vdd = 2; vn_test = 1; cal = 0; vp_test = 0.5; vss = -2; en = 1; DC_bias = 0.4; Fre_tes = 4k; In_V = 0.8
