ADE simulation setup
Test adc_analog_lib_Testbench_1: adc_analog_lib/Testbench/config, simulator ams
  Variables: DC_bias = 0.4; Fre_tes = 4k; In_V = 0.8; vdd = 2; vn_test = 1; cal = 0; vp_test = 0.5; vss = -2; en = 1
  Temperature: 27
  Analysis tran: stop=600u
  Signals: /Clk, /En, /Rst, /Result, /Valid, /net3<0:7>, /net1, /net4
Run mode: Single Run, Sweeps and Corners
