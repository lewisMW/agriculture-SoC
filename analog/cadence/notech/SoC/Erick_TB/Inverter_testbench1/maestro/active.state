ADE simulation setup
Test Testbench_Inverter_testbench1_1: Testbench/Inverter_testbench1/schematic, simulator spectre
  Variables: F_time = 10n; P = 1u; Pulse_with = 50n; R_time = 10n; v1 = 0; v2 = 1; vdd_test = 1; vss_test = 0
  Temperature: 27
  Analysis tran: stop=1m errpreset=moderate
  Analysis dc: sweep /V0.dc start=0 stop=1 (saves the operating point)
  Signals: /net2, /Vout, /I1/vdd (terminal)
Run mode: Single Run, Sweeps and Corners
