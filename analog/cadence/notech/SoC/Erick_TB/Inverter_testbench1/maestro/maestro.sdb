ADE simulation setup
Run mode: Single Run, Sweeps and Corners
Tests:
  Testbench_Inverter_testbench1_1: Testbench/Inverter_testbench1/schematic, simulator spectre
    Variables: F_time = 10n; P = 1u; Pulse_with = 50n; R_time = 10n; v1 = 0; v2 = 1; vdd_test = 1; vss_test = 0
