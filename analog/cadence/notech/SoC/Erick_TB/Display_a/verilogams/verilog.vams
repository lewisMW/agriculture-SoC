//Verilog-AMS HDL for "Testench", "Display_a" "verilogams"

`include "constants.vams"
`include "disciplines.vams"

`timescale 1ns/1ps

module Display_a (
    input        clk,
    input        valid,
    input [7:0]  results
);

    // Print only when ADC says the output is valid
    always @(posedge valid) begin
        $display("TIME = %0t | ADC result = %0d | binary = %b | hex = %h",
                 $time, results, results, results);
    end

endmodule
