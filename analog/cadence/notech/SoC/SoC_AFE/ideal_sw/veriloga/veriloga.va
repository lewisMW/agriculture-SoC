// VerilogA for SoC_probe, ideal_sw, veriloga

`include "constants.vams"
`include "disciplines.vams"

// Simple ideal-ish analog switch: ron when ctrl>vth, roff otherwise
module ideal_sw(p, n, ctrl);
  inout p, n, ctrl;
  electrical p, n, ctrl;

  parameter real vth  = 0.6;     // threshold for "ON"
  parameter real ron  = 1.0;     // ohms
  parameter real roff = 1e12;    // ohms

  analog begin
    if (V(ctrl) > vth)
      I(p,n) <+ V(p,n)/ron;
    else
      I(p,n) <+ V(p,n)/roff;
  end
endmodule
