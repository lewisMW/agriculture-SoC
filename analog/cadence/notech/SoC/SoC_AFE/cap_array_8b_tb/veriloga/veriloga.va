// VerilogA for SoC_probe, cap_array_8b_tb, veriloga

`include "constants.vams"
`include "disciplines.vams"

module cap_array_8b_tb(dummy);

  inout dummy;
  electrical dummy;

  // -------- supplies & nodes --------
  electrical vdd, vss;
  electrical voutp, voutn;

  electrical [7:0] ctlp, ctln;
  electrical ctlp_dummy, ctln_dummy;

  // Precharge reference node + switch controls
  electrical vpre;        // node providing precharge voltage (VCM)
  electrical swpre_p;     // control for precharge switch to voutp
  electrical swpre_n;     // control for precharge switch to voutn

  // -------- parameters --------
  parameter real VDD = 1.2;
  parameter real VSS = 0.0;
  parameter real VCM = 0.6;

  parameter real TR  = 1n;     // transition smoothing for ctl edges
  parameter real TPRE = 200n;  // precharge duration
  parameter real TSTEP = 200n; // time between code changes

  // Your unit cap
  parameter real C = 1p;

  // Total C seen at top plate (your array includes dummy cap = 1*C)
  // Ctot = C*(1 + sum_{k=0..7} 2^k) = C*(1 + 255) = 256*C
  real Ctot;

  // for checker
  integer codep, coden;
  integer prev_codep, prev_coden;

  real voutp_exp, voutn_exp;     // expected outputs (tracked)
  real tol;                      // allowed error

  // -------- DUT --------
  cap_array_8b #(.C(C)) dut (
    .voutp(voutp),
    .voutn(voutn),
    .ctlp(ctlp),
    .ctln(ctln),
    .ctlp_dummy(ctlp_dummy),
    .ctln_dummy(ctln_dummy),
    .vdd(vdd),
    .vss(vss)
  );

  // -------- explicit precharge switches (make floating explicit) --------
  ideal_sw swp(.p(voutp), .n(vpre), .ctrl(swpre_p));
  ideal_sw swn(.p(voutn), .n(vpre), .ctrl(swpre_n));

  // -------- helper function: bottom-plate voltage after inverter --------
  // Assumption: inverter output rail-to-rail:
  //   ctl ~ 0  -> inv out ~ VDD
  //   ctl ~ VDD -> inv out ~ VSS
  analog function real inv_out_from_bit;
    input bitval; // 0 or 1
	integer bitval;
    begin
      inv_out_from_bit = (bitval == 0) ? VDD : VSS;
    end
  endfunction

  // -------- compute expected vout update due to code change --------
  analog function real update_vout_expected;
    input vout_prev;
    input prev_code;
    input new_code;
	input Ctot_in;
	real vout_prev, Ctot_in;
	integer prev_code, new_code;
    integer k;
    real dQ_over_Ctot;
    real vb_prev, vb_new;

    begin
      dQ_over_Ctot = 0.0;

      // Dummy capacitor weight = 1*C (tied to *_dummy inverter output).
      // In this tb we drive ctl*_dummy always 0, so inv output stays at VDD.
      // If you want to toggle dummy too, add it here similarly.
      // For now dVdummy = 0 => no contribution.

      // Binary array caps weights: (1<<k)*C
      for (k=0; k<8; k=k+1) begin
        vb_prev = inv_out_from_bit( (prev_code >> k) & 1 );
        vb_new  = inv_out_from_bit( (new_code  >> k) & 1 );

        // Charge at top plate changes by Ci * dVbottom (sign handled below)
        // For floating top plate: dVtop = - (sum Ci*dVbottom) / Ctot
        dQ_over_Ctot = dQ_over_Ctot + ( (1<<k) * C * (vb_new - vb_prev) );
      end

      update_vout_expected = vout_prev - dQ_over_Ctot / Ctot_in;
    end
  endfunction

  analog begin
    // tie dummy to vss very weakly so it is not floating
    I(dummy, vss) <+ V(dummy, vss)/1e12;  // 1 T?
  end

  // -------- drive supplies + precharge node + controls + ctl waveforms --------
  analog begin
    // constants
    Ctot = 256.0*C;
    tol  = 1e-3; // 1 mV tolerance (tighten/loosen as needed)

    // Supplies
    V(vdd) <+ VDD;
    V(vss) <+ VSS;

    // Precharge source
    V(vpre) <+ VCM;

    // Keep dummy controls fixed (so dummy inverter output is constant)
    V(ctlp_dummy) <+ transition(0.0, 0.0, TR);
    V(ctln_dummy) <+ transition(0.0, 0.0, TR);

    // Precharge switch controls:
    // ON initially, then OFF to float
    V(swpre_p) <+ transition( ( $abstime < TPRE ) ? VDD : 0.0, 0.0, TR);
    V(swpre_n) <+ transition( ( $abstime < TPRE ) ? VDD : 0.0, 0.0, TR);

    // --- code schedule ---
    // You can edit these vectors freely. They occur AFTER precharge opens.
    //
    // Important: ctl signals are electrical nodes, so we drive them with voltages.
    //
    // pattern timeline:
    // t0..TPRE: precharge ON, codes forced to 0
    // then we step through a few test codes

    if ($abstime < TPRE) begin
      codep = 8'h00;
      coden = 8'h00;
    end else if ($abstime < (TPRE + 1*TSTEP)) begin
      codep = 8'h00;
      coden = 8'hFF;
    end else if ($abstime < (TPRE + 2*TSTEP)) begin
      codep = 8'h01;
      coden = 8'hFE;
    end else if ($abstime < (TPRE + 3*TSTEP)) begin
      codep = 8'h80;
      coden = 8'h7F;
    end else if ($abstime < (TPRE + 4*TSTEP)) begin
      codep = 8'h55;
      coden = 8'hAA;
    end else begin
      codep = 8'hA5;
      coden = 8'h5A;
    end

    // Drive each ctl bit as 0 or VDD with a smooth transition
    begin : DRIVE_CTLS
      genvar i;
      for (i=0; i<8; i=i+1) begin
        V(ctlp[i]) <+ transition( ((codep >> i) & 1) ? VDD : 0.0, 0.0, TR );
        V(ctln[i]) <+ transition( ((coden >> i) & 1) ? VDD : 0.0, 0.0, TR );
      end
    end
  end

  // -------- self-checker: track expected Vout after precharge opens --------
  analog begin
    // Initialize expected to VCM once (after precharge settles)
    @(initial_step) begin
      prev_codep = 8'h00;
      prev_coden = 8'h00;
      voutp_exp  = VCM;
      voutn_exp  = VCM;
    end

    // Right after precharge turns OFF, re-sync expected to actual (optional but robust)
    @(timer(TPRE + 5*TR)) begin
      voutp_exp  = V(voutp);
      voutn_exp  = V(voutn);
      prev_codep = codep;
      prev_coden = coden;
      $strobe("INFO: precharge opened @ %g s, synced expected: voutp=%g v, voutn=%g v",
              $abstime, voutp_exp, voutn_exp);
    end

    // Each time we *intend* a step boundary, update expected and check shortly after
    // (check after a small delay so analog settles)
    begin : STEP_CHECKS
      integer s;
      real tcheck, tapply;

      // We placed steps at: TPRE + n*TSTEP, for n=1..5
      for (s=1; s<=5; s=s+1) begin
        tapply = TPRE + s*TSTEP;
        tcheck = tapply + 20*TR;

        @(timer(tapply)) begin
          // update expected using previous->new code
          voutp_exp = update_vout_expected(voutp_exp, prev_codep, codep, Ctot);
          voutn_exp = update_vout_expected(voutn_exp, prev_coden, coden, Ctot);
          prev_codep = codep;
          prev_coden = coden;

          $strobe("STEP @ %g s: codep=%0h coden=%0h | expected voutp=%g v voutn=%g v",
                  $abstime, codep, coden, voutp_exp, voutn_exp);
        end

        @(timer(tcheck)) begin
          if (abs(V(voutp) - voutp_exp) > tol)
            $strobe("FAIL voutp @ %g s: actual=%g expected=%g (err=%g)",
                    $abstime, V(voutp), voutp_exp, V(voutp)-voutp_exp);

          if (abs(V(voutn) - voutn_exp) > tol)
            $strobe("FAIL voutn @ %g s: actual=%g expected=%g (err=%g)",
                    $abstime, V(voutn), voutn_exp, V(voutn)-voutn_exp);
        end
      end
    end
  end

endmodule
