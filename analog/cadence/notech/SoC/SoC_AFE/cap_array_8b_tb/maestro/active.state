ADE simulation setup
Test SoC_AFE_cap_array_8b_tb_1: SoC_AFE/cap_array_8b_tb/schematic, simulator spectre
  Variables: V1 = 1.8; V2 = 0; clk = 100n
  Temperature: 27
  Stimulus vdd!: voltage dc dc=V1 srcType=dc
  Stimulus vss!: voltage dc dc=V2 srcType=dc
  Stimulus ctrl_swi: voltage bit val1=V1 val0=V2 period=10n srcType=bit data=10 rptstart=2
  Stimulus ctlp<7>: voltage bit val1=V1 val0=V2 delay=10n rise=10p fall=10p period=clk srcType=bit data=00101 rpttimes=-1
  Stimulus ctlp<6>: voltage bit val1=V1 val0=V2 delay=10n rise=10p fall=10p period=clk srcType=bit data=00011 rpttimes=-1
  Stimulus ctlp<5>: voltage bit val1=V1 val0=V2 delay=10n rise=10p fall=10p period=clk srcType=bit data=00011 rpttimes=-1
  Stimulus ctlp<4>: voltage bit val1=V1 val0=V2 delay=10n rise=10p fall=10p period=clk srcType=bit data=00101 rpttimes=-1
  Stimulus ctlp<3>: voltage bit val1=V1 val0=V2 delay=10n rise=10p fall=10p period=clk srcType=bit data=00101 rpttimes=-1
  Stimulus ctlp<2>: voltage bit val1=V1 val0=V2 delay=10n rise=10p fall=10p period=clk srcType=bit data=00101 rpttimes=-1
  Stimulus ctlp<1>: voltage bit val1=V1 val0=V2 delay=10n rise=10p fall=10p period=clk srcType=bit data=00010 rpttimes=-1
  Stimulus ctlp<0>: voltage bit val1=V1 val0=V2 delay=10n rise=10p fall=10p period=clk srcType=bit data=00010 rpttimes=-1
  Stimulus ctlp_dummy: voltage dc dc=V2 srcType=dc
  Stimulus ctln<7>: voltage bit val1=V1 val0=V2 delay=10n rise=10p fall=10p period=clk srcType=bit data=00101 rpttimes=-1
  Stimulus ctln<6>: voltage bit val1=V1 val0=V2 delay=10n rise=10p fall=10p period=clk srcType=bit data=00011 rpttimes=-1
  Stimulus ctln<5>: voltage bit val1=V1 val0=V2 delay=10n rise=10p fall=10p period=clk srcType=bit data=00011 rpttimes=-1
  Stimulus ctln<4>: voltage bit val1=V1 val0=V2 delay=10n rise=10p fall=10p period=clk srcType=bit data=00101 rpttimes=-1
  Stimulus ctln<3>: voltage bit val1=V1 val0=V2 delay=10n rise=10p fall=10p period=clk srcType=bit data=00101 rpttimes=-1
  Stimulus ctln<2>: voltage bit val1=V1 val0=V2 delay=10n rise=10p fall=10p period=clk srcType=bit data=00101 rpttimes=-1
  Stimulus ctln<1>: voltage bit val1=V1 val0=V2 delay=10n rise=10p fall=10p period=clk srcType=bit data=00010 rpttimes=-1
  Stimulus ctln<0>: voltage bit val1=V1 val0=V2 delay=10n rise=10p fall=10p period=clk srcType=bit data=00010 rpttimes=-1
  Stimulus ctln_dummy: voltage dc dc=V1 srcType=dc
  Analysis tran: stop=2u
  Signals: /p_out, /n_out, /ctlp<7:0>
Run mode: Single Run, Sweeps and Corners
