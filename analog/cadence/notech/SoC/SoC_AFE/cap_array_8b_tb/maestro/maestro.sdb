ADE simulation setup
Run mode: Single Run, Sweeps and Corners
Tests:
  SoC_AFE_cap_array_8b_tb_1: SoC_AFE/cap_array_8b_tb/schematic, simulator spectre
    Variables: V1 = 1.8; V2 = 0; clk = 100n
    Outputs: /p_out; /n_out; /ctlp<7:0>
