// VerilogAMS for SoC_probe, cap_array_8b, verilogams

`include "constants.vams"
`include "disciplines.vams"

// ------------------------------------------------------------
// Module: cap_array_8b
// Description:
//   8-bit binary-weighted capacitive DAC for SAR ADC.
//   Bottom plates are driven by digital control signals.
//   Top plate node: vout.
//
// Function:
//   Implements charge redistribution DAC.
//
// Assumptions:
//   - Ideal capacitors (no parasitics)
//   - No mismatch
//   - No charge injection modeled here
//
// Author: Hee
// Date: 2026-02
// ------------------------------------------------------------
module cap_array_8b_cp(voutp, voutn, ctlp, ctln, ctlp_dummy, ctln_dummy, vdd, vss);
inout voutp, voutn, ctlp_dummy, ctln_dummy, vdd, vss;
inout [7:0] ctlp, ctln;
electrical [7:0] ctlp, ctln; // control lines  coming from the SAR FSM
electrical voutp, voutn, ctlp_dummy, ctln_dummy, vdd, vss;
electrical np_dummy, nn_dummy; // dummy nodes between inverter and capacitor
electrical [7:0] np, nn; // nodes between inverter and capacitor.

parameter real C=1p from (0:inf);

// ----------------------------------------------------------------
// inverters between control lines and capacitors for p and n lines
// ----------------------------------------------------------------
inverter invp_dummy (.out(np_dummy), .in(ctlp_dummy), .vdd(vdd), .vss(vss));
inverter invp1 (.out(np[0]), .in(ctlp[0]), .vdd(vdd), .vss(vss));
inverter invp2 (.out(np[1]), .in(ctlp[1]), .vdd(vdd), .vss(vss));
inverter invp3 (.out(np[2]), .in(ctlp[2]), .vdd(vdd), .vss(vss));
inverter invp4 (.out(np[3]), .in(ctlp[3]), .vdd(vdd), .vss(vss));
inverter invp5 (.out(np[4]), .in(ctlp[4]), .vdd(vdd), .vss(vss));
inverter invp6 (.out(np[5]), .in(ctlp[5]), .vdd(vdd), .vss(vss));
inverter invp7 (.out(np[6]), .in(ctlp[6]), .vdd(vdd), .vss(vss));
inverter invp8 (.out(np[7]), .in(ctlp[7]), .vdd(vdd), .vss(vss));

inverter invn_dummy (.out(nn_dummy), .in(ctln_dummy), .vdd(vdd), .vss(vss));
inverter invn1 (.out(nn[0]), .in(ctln[0]), .vdd(vdd), .vss(vss));
inverter invn2 (.out(nn[1]), .in(ctln[1]), .vdd(vdd), .vss(vss));
inverter invn3 (.out(nn[2]), .in(ctln[2]), .vdd(vdd), .vss(vss));
inverter invn4 (.out(nn[3]), .in(ctln[3]), .vdd(vdd), .vss(vss));
inverter invn5 (.out(nn[4]), .in(ctln[4]), .vdd(vdd), .vss(vss));
inverter invn6 (.out(nn[5]), .in(ctln[5]), .vdd(vdd), .vss(vss));
inverter invn7 (.out(nn[6]), .in(ctln[6]), .vdd(vdd), .vss(vss));
inverter invn8 (.out(nn[7]), .in(ctln[7]), .vdd(vdd), .vss(vss));

// ----------------------------------------------------------------
// capacitor connections p and n lines
// ----------------------------------------------------------------
genvar k;

analog begin
	// --- Capacitor array p line ---
	I(voutp,np_dummy) <+ ddt(V(voutp,np_dummy))*(1*C);
	I(voutn,nn_dummy) <+ ddt(V(voutn,nn_dummy))*(1*C);
	for (k=0; k<8; k=k+1) begin
		I(voutp,np[k]) <+ (C*(1<<k)) * ddt(V(voutp,np[k]));
		I(voutn,nn[k]) <+ (C*(1<<k)) * ddt(V(voutn,nn[k]));
	end
/*
	I(voutp,np[0]) <+ ddt(V(voutp,np[0]))*(1*C);
	I(voutp,np[1]) <+ ddt(V(voutp,np[1]))*(2*C);
	I(voutp,np[2]) <+ ddt(V(voutp,np[2]))*(4*C);
	I(voutp,np[3]) <+ ddt(V(voutp,np[3]))*(8*C);
	I(voutp,np[4]) <+ ddt(V(voutp,np[4]))*(16*C);
	I(voutp,np[5]) <+ ddt(V(voutp,np[5]))*(32*C);
	I(voutp,np[6]) <+ ddt(V(voutp,np[6]))*(64*C);
	I(voutp,np[7]) <+ ddt(V(voutp,np[7]))*(128*C);

	I(voutn,nn[0]) <+ ddt(V(voutn,nn[0]))*(1*C);
	I(voutn,nn[1]) <+ ddt(V(voutn,nn[1]))*(2*C);
	I(voutn,nn[2]) <+ ddt(V(voutn,nn[2]))*(4*C);
	I(voutn,nn[3]) <+ ddt(V(voutn,nn[3]))*(8*C);
	I(voutn,nn[4]) <+ ddt(V(voutn,nn[4]))*(16*C);
	I(voutn,nn[5]) <+ ddt(V(voutn,nn[5]))*(32*C);
	I(voutn,nn[6]) <+ ddt(V(voutn,nn[6]))*(64*C);
	I(voutn,nn[7]) <+ ddt(V(voutn,nn[7]))*(128*C);
*/
end

endmodule
