ADE simulation setup
Test SoC_probe_ADC_tb_1: SoC_probe/ADC_tb/config, simulator ams
  Temperature: 27
  Analysis tran: stop=0.002
  Signals: /DATA<7:0> as DATA, /clk as clk, /data_valid as data_valid, /EXTIN as EXTIN, /resetn as resetn
Run mode: Single Run, Sweeps and Corners
