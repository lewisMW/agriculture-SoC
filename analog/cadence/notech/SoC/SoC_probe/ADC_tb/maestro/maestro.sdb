ADE simulation setup
Run mode: Single Run, Sweeps and Corners
Tests:
  SoC_probe_ADC_tb_1: SoC_probe/ADC_tb/config, simulator ams
    Outputs: "/clk"; nil; "/EXTIN"; (dut / clk); EXTIN; DATA; clk; data_valid; resetn
