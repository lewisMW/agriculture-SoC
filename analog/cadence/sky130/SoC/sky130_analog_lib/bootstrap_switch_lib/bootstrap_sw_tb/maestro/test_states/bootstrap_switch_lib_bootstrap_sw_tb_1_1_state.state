ADE simulation setup
Test bootstrap_switch_lib_bootstrap_sw_tb_1_1: bootstrap_switch_lib/bootstrap_sw_tb/config, simulator spectre
  Models: /home/jaime/sky130_release_0.1.0/libs/sky130_fd_pr_main/../../models/sky130.lib.spice[tt]
  Variables: vin = 1
  Temperature: 27
  Analysis tran: stop=60u
  Signals: /vin, /vout, /en, /bs_switch/vbsh, /bs_switch/vbsl, /bs_switch/net2, /bs_switch/enb
