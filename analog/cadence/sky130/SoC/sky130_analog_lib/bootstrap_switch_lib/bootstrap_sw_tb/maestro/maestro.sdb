ADE simulation setup
Run mode: Single Run, Sweeps and Corners
Tests:
  bootstrap_switch_lib_bootstrap_sw_tb_1: bootstrap_switch_lib/bootstrap_sw_tb/config, simulator spectre
    Variables: vin = 1
    Outputs: /vin; /vout; /en; /C0/PLUS; /bs_switch/vbsh; /bs_switch/vbsl; /bs_switch/net2; /bs_switch/enb; "/"
