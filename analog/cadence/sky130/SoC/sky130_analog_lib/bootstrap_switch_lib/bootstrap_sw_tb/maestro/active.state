ADE simulation setup
Test bootstrap_switch_lib_bootstrap_sw_tb_1: bootstrap_switch_lib/bootstrap_sw_tb/schematic, simulator spectre
  Models: /home/jaime/sky130_release_0.1.0/libs/sky130_fd_pr_main/../../models/sky130.lib.spice[tt]
  Variables: vin = 1
  Temperature: 27
  Analysis dc: (saves the operating point)
  Analysis tran: stop=1m
  Signals: /vin, /vout, /en
Run mode: Single Run, Sweeps and Corners
