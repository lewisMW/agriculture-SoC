ADE simulation setup
Run mode: Single Run, Sweeps and Corners
Tests:
  SoC_Trim_tb_1: SoC/Trim_tb/schematic, simulator spectre
    Variables: d0 = 0,1.8; d1 = 0,1.8; d2 = 0,1.8; d3 = 0,1.8; d4 = 0,1.8
    Outputs: (abs(imag((I "/V7/PLUS"))) / (2 * pi * 100000))
