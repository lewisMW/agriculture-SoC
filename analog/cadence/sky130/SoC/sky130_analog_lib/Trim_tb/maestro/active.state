ADE simulation setup
Test SoC_Trim_tb_1: SoC/Trim_tb/schematic, simulator spectre
  Models: /home/admin/Documents/PDKs/sky130_release_0.1.0/libs/sky130_fd_pr_main/../../models/sky130.lib.spice[tt]
  Variables: d0 = 0,1.8; d1 = 0; d2 = 0; d3 = 0; d4 = 0
  Temperature: 27
  Analysis ac: start=1 stop=10M
  Output i /V7/PLUS; ac mag(I) = ifreq('ac "/V7/PLUS") (unticked)
  Output imag(ifreq('ac "/V7/PLUS")) (unticked)
  Output (abs(imag((I "/V7/PLUS"))) / (2 * pi * 100000))
  Output (abs(imag(IF("/V7/PLUS"))) / (2 * pi * xval(IF("/V7/PLUS"))))
  Output (abs(imag(value(IF("/V7/PLUS") 100000))) / (2 * pi * 100000))
  Signals: /V7/PLUS (terminal)
Run mode: Single Run, Sweeps and Corners
Setup values for test SoC_Trim_tb_1: d1 = 0,1.8; d2 = 0,1.8; d3 = 0,1.8; d4 = 0,1.8
