ADE simulation setup
Test SoC_Comparator_sky130_tb_1: SoC/Comparator_sky130_tb/config, simulator ams
  Models: /home/admin/Documents/PDKs/gpdk090_v4.6/libs.oa22/gpdk090/../../models/spectre/gpdk090.scs[NN], /home/admin/Documents/PDKs/sky130_release_0.1.0/libs/sky130_fd_pr_main/../../models/sky130.lib.spice[tt]
  Variables: Vdd = 1.8; Vss = -1.8; vcm = 0.5
  Temperature: 27
  Analysis tran: stop=1.2m
  Signals: /Trimb<4:0>, /Trima<4:0>, /Vn, /Vp, /Out_N, /Out_P, /Clk, /Vpositive
Run mode: Single Run, Sweeps and Corners
