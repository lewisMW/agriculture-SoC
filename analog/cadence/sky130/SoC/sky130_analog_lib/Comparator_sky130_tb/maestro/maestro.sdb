ADE simulation setup
Run mode: Single Run, Sweeps and Corners
Tests:
  SoC_Comparator_sky130_tb_1: SoC/Comparator_sky130_tb/config, simulator ams
    Variables: Vdd = 1.8; Vss = -1.8; vcm = 0.5
    Outputs: /Trimb<4:0>; /Trima<4:0>; /Vpositive
