ADE simulation setup
Run mode: Single Run, Sweeps and Corners
Tests:
  SoC_Comparator_1: SoC/Comparator/schematic, simulator spectre
