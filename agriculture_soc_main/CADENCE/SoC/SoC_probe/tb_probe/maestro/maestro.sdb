ADE simulation setup
Run mode: Single Run, Sweeps and Corners
Tests:
  SoC_probe_probe_1: SoC_probe/probe/schematic, simulator spectre
    Variables: L = 1G; C_probe = 8.78e-10; G_probe = 0.012408; L_probe = 2.75e-8; R_probe = 1
    Outputs: /vp
  SoC_probe_probe_2: SoC_probe/probe/config, simulator ams
    Variables: C_probe = 8.78e-10; G_probe = 0.012408; L = 1G; L_probe = 2.75e-8; R_probe = 1
    Outputs: DATA; data_valid; EXTIN; CLK; reset
Global variables (all switched off):
  L = 1G
  C_probe = {Inclusion List}1{Inclusion List}{From/To}Auto:0.22e-10:10:8.78e-10{From/To}
