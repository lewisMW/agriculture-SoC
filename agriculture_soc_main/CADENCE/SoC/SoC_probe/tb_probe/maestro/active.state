ADE simulation setup
Test SoC_probe_probe_1: SoC_probe/probe/schematic, simulator spectre
  Models: /home/hee/cadence/lib/gpdk045/gpdk045/../models/spectre/gpdk045.scs[mc]
  Variables: L = 1G; C_probe = 8.78e-10; G_probe = 0.012408; L_probe = 2.75e-8; R_probe = 1
  Temperature: 27
  Analysis tran: stop=500n errpreset=conservative
  Signals: /vs, /vi, /vp
Test SoC_probe_probe_2: SoC_probe/probe/config, simulator ams
  Models: /home/hee/cadence/lib/gpdk045/gpdk045/../models/spectre/gpdk045.scs[mc]
  Variables: C_probe = 8.78e-10; G_probe = 0.012408; L = 1G; L_probe = 2.75e-8; R_probe = 1
  Temperature: 27
  Analysis tran: stop=100m
  Signals: /DATA<7:0> as DATA, /data_valid as data_valid, /vin as EXTIN, /clk as CLK, /rst as reset
Run mode: Single Run, Sweeps and Corners
Global variables (all switched off):
  L = 1G
  C_probe = {Inclusion List}1{Inclusion List}{From/To}Auto:0.22e-10:10:8.78e-10{From/To}
