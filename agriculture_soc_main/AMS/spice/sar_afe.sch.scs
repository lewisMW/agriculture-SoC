// GENERATED by analog/cadence/pv/netlist_spectre.sh from OA sar_adc/sar_afe
// view list: spectre cmos_sch cmos.sch schematic veriloga -- do not edit by hand
subckt mim_cap_adc bottom top vssa
    C0 (top bottom) cap_mim_m3_1 l=4u w=4u m=1
ends mim_cap_adc
subckt mim_cap_128bank bottom top vssa
    C127 (bottom top vssa) mim_cap_adc
    C126 (bottom top vssa) mim_cap_adc
    C125 (bottom top vssa) mim_cap_adc
    C124 (bottom top vssa) mim_cap_adc
    C123 (bottom top vssa) mim_cap_adc
    C122 (bottom top vssa) mim_cap_adc
    C121 (bottom top vssa) mim_cap_adc
    C120 (bottom top vssa) mim_cap_adc
    C119 (bottom top vssa) mim_cap_adc
    C118 (bottom top vssa) mim_cap_adc
    C117 (bottom top vssa) mim_cap_adc
    C116 (bottom top vssa) mim_cap_adc
    C115 (bottom top vssa) mim_cap_adc
    C114 (bottom top vssa) mim_cap_adc
    C113 (bottom top vssa) mim_cap_adc
    C112 (bottom top vssa) mim_cap_adc
    C111 (bottom top vssa) mim_cap_adc
    C110 (bottom top vssa) mim_cap_adc
    C109 (bottom top vssa) mim_cap_adc
    C108 (bottom top vssa) mim_cap_adc
    C107 (bottom top vssa) mim_cap_adc
    C106 (bottom top vssa) mim_cap_adc
    C105 (bottom top vssa) mim_cap_adc
    C104 (bottom top vssa) mim_cap_adc
    C103 (bottom top vssa) mim_cap_adc
    C102 (bottom top vssa) mim_cap_adc
    C101 (bottom top vssa) mim_cap_adc
    C100 (bottom top vssa) mim_cap_adc
    C99 (bottom top vssa) mim_cap_adc
    C98 (bottom top vssa) mim_cap_adc
    C97 (bottom top vssa) mim_cap_adc
    C96 (bottom top vssa) mim_cap_adc
    C95 (bottom top vssa) mim_cap_adc
    C94 (bottom top vssa) mim_cap_adc
    C93 (bottom top vssa) mim_cap_adc
    C92 (bottom top vssa) mim_cap_adc
    C91 (bottom top vssa) mim_cap_adc
    C90 (bottom top vssa) mim_cap_adc
    C89 (bottom top vssa) mim_cap_adc
    C88 (bottom top vssa) mim_cap_adc
    C87 (bottom top vssa) mim_cap_adc
    C86 (bottom top vssa) mim_cap_adc
    C85 (bottom top vssa) mim_cap_adc
    C84 (bottom top vssa) mim_cap_adc
    C83 (bottom top vssa) mim_cap_adc
    C82 (bottom top vssa) mim_cap_adc
    C81 (bottom top vssa) mim_cap_adc
    C80 (bottom top vssa) mim_cap_adc
    C79 (bottom top vssa) mim_cap_adc
    C78 (bottom top vssa) mim_cap_adc
    C77 (bottom top vssa) mim_cap_adc
    C76 (bottom top vssa) mim_cap_adc
    C75 (bottom top vssa) mim_cap_adc
    C74 (bottom top vssa) mim_cap_adc
    C73 (bottom top vssa) mim_cap_adc
    C72 (bottom top vssa) mim_cap_adc
    C71 (bottom top vssa) mim_cap_adc
    C70 (bottom top vssa) mim_cap_adc
    C69 (bottom top vssa) mim_cap_adc
    C68 (bottom top vssa) mim_cap_adc
    C67 (bottom top vssa) mim_cap_adc
    C66 (bottom top vssa) mim_cap_adc
    C65 (bottom top vssa) mim_cap_adc
    C64 (bottom top vssa) mim_cap_adc
    C63 (bottom top vssa) mim_cap_adc
    C62 (bottom top vssa) mim_cap_adc
    C61 (bottom top vssa) mim_cap_adc
    C60 (bottom top vssa) mim_cap_adc
    C59 (bottom top vssa) mim_cap_adc
    C58 (bottom top vssa) mim_cap_adc
    C57 (bottom top vssa) mim_cap_adc
    C56 (bottom top vssa) mim_cap_adc
    C55 (bottom top vssa) mim_cap_adc
    C54 (bottom top vssa) mim_cap_adc
    C53 (bottom top vssa) mim_cap_adc
    C52 (bottom top vssa) mim_cap_adc
    C51 (bottom top vssa) mim_cap_adc
    C50 (bottom top vssa) mim_cap_adc
    C49 (bottom top vssa) mim_cap_adc
    C48 (bottom top vssa) mim_cap_adc
    C47 (bottom top vssa) mim_cap_adc
    C46 (bottom top vssa) mim_cap_adc
    C45 (bottom top vssa) mim_cap_adc
    C44 (bottom top vssa) mim_cap_adc
    C43 (bottom top vssa) mim_cap_adc
    C42 (bottom top vssa) mim_cap_adc
    C41 (bottom top vssa) mim_cap_adc
    C40 (bottom top vssa) mim_cap_adc
    C39 (bottom top vssa) mim_cap_adc
    C38 (bottom top vssa) mim_cap_adc
    C37 (bottom top vssa) mim_cap_adc
    C36 (bottom top vssa) mim_cap_adc
    C35 (bottom top vssa) mim_cap_adc
    C34 (bottom top vssa) mim_cap_adc
    C33 (bottom top vssa) mim_cap_adc
    C32 (bottom top vssa) mim_cap_adc
    C31 (bottom top vssa) mim_cap_adc
    C30 (bottom top vssa) mim_cap_adc
    C29 (bottom top vssa) mim_cap_adc
    C28 (bottom top vssa) mim_cap_adc
    C27 (bottom top vssa) mim_cap_adc
    C26 (bottom top vssa) mim_cap_adc
    C25 (bottom top vssa) mim_cap_adc
    C24 (bottom top vssa) mim_cap_adc
    C23 (bottom top vssa) mim_cap_adc
    C22 (bottom top vssa) mim_cap_adc
    C21 (bottom top vssa) mim_cap_adc
    C20 (bottom top vssa) mim_cap_adc
    C19 (bottom top vssa) mim_cap_adc
    C18 (bottom top vssa) mim_cap_adc
    C17 (bottom top vssa) mim_cap_adc
    C16 (bottom top vssa) mim_cap_adc
    C15 (bottom top vssa) mim_cap_adc
    C14 (bottom top vssa) mim_cap_adc
    C13 (bottom top vssa) mim_cap_adc
    C12 (bottom top vssa) mim_cap_adc
    C11 (bottom top vssa) mim_cap_adc
    C10 (bottom top vssa) mim_cap_adc
    C9 (bottom top vssa) mim_cap_adc
    C8 (bottom top vssa) mim_cap_adc
    C7 (bottom top vssa) mim_cap_adc
    C6 (bottom top vssa) mim_cap_adc
    C5 (bottom top vssa) mim_cap_adc
    C4 (bottom top vssa) mim_cap_adc
    C3 (bottom top vssa) mim_cap_adc
    C2 (bottom top vssa) mim_cap_adc
    C1 (bottom top vssa) mim_cap_adc
    C0 (bottom top vssa) mim_cap_adc
ends mim_cap_128bank
subckt mim_cap_64bank bottom top vssa
    C63 (bottom top vssa) mim_cap_adc
    C62 (bottom top vssa) mim_cap_adc
    C61 (bottom top vssa) mim_cap_adc
    C60 (bottom top vssa) mim_cap_adc
    C59 (bottom top vssa) mim_cap_adc
    C58 (bottom top vssa) mim_cap_adc
    C57 (bottom top vssa) mim_cap_adc
    C56 (bottom top vssa) mim_cap_adc
    C55 (bottom top vssa) mim_cap_adc
    C54 (bottom top vssa) mim_cap_adc
    C53 (bottom top vssa) mim_cap_adc
    C52 (bottom top vssa) mim_cap_adc
    C51 (bottom top vssa) mim_cap_adc
    C50 (bottom top vssa) mim_cap_adc
    C49 (bottom top vssa) mim_cap_adc
    C48 (bottom top vssa) mim_cap_adc
    C47 (bottom top vssa) mim_cap_adc
    C46 (bottom top vssa) mim_cap_adc
    C45 (bottom top vssa) mim_cap_adc
    C44 (bottom top vssa) mim_cap_adc
    C43 (bottom top vssa) mim_cap_adc
    C42 (bottom top vssa) mim_cap_adc
    C41 (bottom top vssa) mim_cap_adc
    C40 (bottom top vssa) mim_cap_adc
    C39 (bottom top vssa) mim_cap_adc
    C38 (bottom top vssa) mim_cap_adc
    C37 (bottom top vssa) mim_cap_adc
    C36 (bottom top vssa) mim_cap_adc
    C35 (bottom top vssa) mim_cap_adc
    C34 (bottom top vssa) mim_cap_adc
    C33 (bottom top vssa) mim_cap_adc
    C32 (bottom top vssa) mim_cap_adc
    C31 (bottom top vssa) mim_cap_adc
    C30 (bottom top vssa) mim_cap_adc
    C29 (bottom top vssa) mim_cap_adc
    C28 (bottom top vssa) mim_cap_adc
    C27 (bottom top vssa) mim_cap_adc
    C26 (bottom top vssa) mim_cap_adc
    C25 (bottom top vssa) mim_cap_adc
    C24 (bottom top vssa) mim_cap_adc
    C23 (bottom top vssa) mim_cap_adc
    C22 (bottom top vssa) mim_cap_adc
    C21 (bottom top vssa) mim_cap_adc
    C20 (bottom top vssa) mim_cap_adc
    C19 (bottom top vssa) mim_cap_adc
    C18 (bottom top vssa) mim_cap_adc
    C17 (bottom top vssa) mim_cap_adc
    C16 (bottom top vssa) mim_cap_adc
    C15 (bottom top vssa) mim_cap_adc
    C14 (bottom top vssa) mim_cap_adc
    C13 (bottom top vssa) mim_cap_adc
    C12 (bottom top vssa) mim_cap_adc
    C11 (bottom top vssa) mim_cap_adc
    C10 (bottom top vssa) mim_cap_adc
    C9 (bottom top vssa) mim_cap_adc
    C8 (bottom top vssa) mim_cap_adc
    C7 (bottom top vssa) mim_cap_adc
    C6 (bottom top vssa) mim_cap_adc
    C5 (bottom top vssa) mim_cap_adc
    C4 (bottom top vssa) mim_cap_adc
    C3 (bottom top vssa) mim_cap_adc
    C2 (bottom top vssa) mim_cap_adc
    C1 (bottom top vssa) mim_cap_adc
    C0 (bottom top vssa) mim_cap_adc
ends mim_cap_64bank
subckt mim_cap_32bank bottom top vssa
    C31 (bottom top vssa) mim_cap_adc
    C30 (bottom top vssa) mim_cap_adc
    C29 (bottom top vssa) mim_cap_adc
    C28 (bottom top vssa) mim_cap_adc
    C27 (bottom top vssa) mim_cap_adc
    C26 (bottom top vssa) mim_cap_adc
    C25 (bottom top vssa) mim_cap_adc
    C24 (bottom top vssa) mim_cap_adc
    C23 (bottom top vssa) mim_cap_adc
    C22 (bottom top vssa) mim_cap_adc
    C21 (bottom top vssa) mim_cap_adc
    C20 (bottom top vssa) mim_cap_adc
    C19 (bottom top vssa) mim_cap_adc
    C18 (bottom top vssa) mim_cap_adc
    C17 (bottom top vssa) mim_cap_adc
    C16 (bottom top vssa) mim_cap_adc
    C15 (bottom top vssa) mim_cap_adc
    C14 (bottom top vssa) mim_cap_adc
    C13 (bottom top vssa) mim_cap_adc
    C12 (bottom top vssa) mim_cap_adc
    C11 (bottom top vssa) mim_cap_adc
    C10 (bottom top vssa) mim_cap_adc
    C9 (bottom top vssa) mim_cap_adc
    C8 (bottom top vssa) mim_cap_adc
    C7 (bottom top vssa) mim_cap_adc
    C6 (bottom top vssa) mim_cap_adc
    C5 (bottom top vssa) mim_cap_adc
    C4 (bottom top vssa) mim_cap_adc
    C3 (bottom top vssa) mim_cap_adc
    C2 (bottom top vssa) mim_cap_adc
    C1 (bottom top vssa) mim_cap_adc
    C0 (bottom top vssa) mim_cap_adc
ends mim_cap_32bank
subckt mim_cap_16bank bottom top vssa
    C15 (bottom top vssa) mim_cap_adc
    C14 (bottom top vssa) mim_cap_adc
    C13 (bottom top vssa) mim_cap_adc
    C12 (bottom top vssa) mim_cap_adc
    C11 (bottom top vssa) mim_cap_adc
    C10 (bottom top vssa) mim_cap_adc
    C9 (bottom top vssa) mim_cap_adc
    C8 (bottom top vssa) mim_cap_adc
    C7 (bottom top vssa) mim_cap_adc
    C6 (bottom top vssa) mim_cap_adc
    C5 (bottom top vssa) mim_cap_adc
    C4 (bottom top vssa) mim_cap_adc
    C3 (bottom top vssa) mim_cap_adc
    C2 (bottom top vssa) mim_cap_adc
    C1 (bottom top vssa) mim_cap_adc
    C0 (bottom top vssa) mim_cap_adc
ends mim_cap_16bank
subckt mim_cap_8bank bottom top vssa
    C7 (bottom top vssa) mim_cap_adc
    C6 (bottom top vssa) mim_cap_adc
    C5 (bottom top vssa) mim_cap_adc
    C4 (bottom top vssa) mim_cap_adc
    C3 (bottom top vssa) mim_cap_adc
    C2 (bottom top vssa) mim_cap_adc
    C1 (bottom top vssa) mim_cap_adc
    C0 (bottom top vssa) mim_cap_adc
ends mim_cap_8bank
subckt mim_cap_4bank bottom top vssa
    C3 (bottom top vssa) mim_cap_adc
    C2 (bottom top vssa) mim_cap_adc
    C1 (bottom top vssa) mim_cap_adc
    C0 (bottom top vssa) mim_cap_adc
ends mim_cap_4bank
subckt mim_cap_2bank bottom top vssa
    C1 (bottom top vssa) mim_cap_adc
    C0 (bottom top vssa) mim_cap_adc
ends mim_cap_2bank
subckt carray_8b vbottom\<7\> vbottom\<6\> vbottom\<5\> vbottom\<4\> \
        vbottom\<3\> vbottom\<2\> vbottom\<1\> vbottom\<0\> vbottom_dum \
        vtop vssa
    C7 (vbottom\<7\> vtop vssa) mim_cap_128bank
    C8 (vbottom_dum vtop vssa) mim_cap_adc
    C0 (vbottom\<0\> vtop vssa) mim_cap_adc
    C9 (vssa vssa vssa) mim_cap_64bank
    C6 (vbottom\<6\> vtop vssa) mim_cap_64bank
    C5 (vbottom\<5\> vtop vssa) mim_cap_32bank
    C4 (vbottom\<4\> vtop vssa) mim_cap_16bank
    C3 (vbottom\<3\> vtop vssa) mim_cap_8bank
    C10 (vssa vssa vssa) mim_cap_4bank
    C2 (vbottom\<2\> vtop vssa) mim_cap_4bank
    C1 (vbottom\<1\> vtop vssa) mim_cap_2bank
ends carray_8b
subckt inverter in out vdd vss
    NM0 (out in vss vss) nfet_01v8 w=(420n) l=150n as=111.3f ad=111.3f \
        ps=1.37u pd=1.37u m=(1)*(1)
    PM0 (out in vdd vdd) pfet_01v8 w=(550n) l=150n as=145.75f ad=145.75f \
        ps=1.63u pd=1.63u m=(1)*(1)
ends inverter
subckt inv_lvt in out vdd vss
    NM0 (out in vss vss) nfet_01v8_lvt w=(420n) l=150n as=111.3f ad=111.3f \
        ps=1.37u pd=1.37u m=(1)*(1)
    PM0 (out in vdd vdd) pfet_01v8_lvt w=(550n) l=350n as=145.75f \
        ad=145.75f ps=1.63u pd=1.63u m=(1)*(1)
ends inv_lvt
subckt bootstrap_sw en in out vdd vss
    Ms2 (vss enb net30 vss) nfet_01v8_lvt w=(1u) l=400n as=265f ad=265f \
        ps=2.53u pd=2.53u m=(1)*(1)
    Ms1 (net30 vdd net2 vss) nfet_01v8_lvt w=(1u) l=400n as=265f ad=265f \
        ps=2.53u pd=2.53u m=(1)*(1)
    Ms (out net2 in vss) nfet_01v8_lvt w=(1u) l=500n as=265f ad=265f \
        ps=2.53u pd=2.53u m=(1)*(1)
    M1 (vbsl net2 in vss) nfet_01v8_lvt w=(1u) l=400n as=265f ad=265f \
        ps=2.53u pd=2.53u m=(1)*(1)
    M2 (vbsl enb vss vss) nfet_01v8_lvt w=(1u) l=400n as=265f ad=265f \
        ps=2.53u pd=2.53u m=(1)*(1)
    M4 (net2 enb vbsh vbsh) pfet_01v8_lvt w=(1u) l=400n as=265f ad=265f \
        ps=2.53u pd=2.53u m=(1)*(1)
    M3 (vdd net2 vbsh vbsh) pfet_01v8_lvt w=(1u) l=400n as=265f ad=265f \
        ps=2.53u pd=2.53u m=(1)*(1)
    C4 (vbsh vbsl) cap_mim_m3_1 l=5u w=5u m=1
    C2 (vbsh vbsl) cap_mim_m3_1 l=5u w=5u m=1
    C1 (vbsh vbsl) cap_mim_m3_1 l=5u w=5u m=1
    C0 (vbsh vbsl) cap_mim_m3_1 l=5u w=5u m=1
    inv_lvt0 (en enb vdd vss) inv_lvt
ends bootstrap_sw
subckt cdac_8b ctl\<7\> ctl\<6\> ctl\<5\> ctl\<4\> ctl\<3\> ctl\<2\> \
        ctl\<1\> ctl\<0\> ctl_dum sample vdda vin vout vref vssa
    I0 (vbottom\<7\> vbottom\<6\> vbottom\<5\> vbottom\<4\> vbottom\<3\> \
        vbottom\<2\> vbottom\<1\> vbottom\<0\> net3 vout vssa) carray_8b
    I9 (ctl_dum net3 vref vssa) inverter
    I8 (ctl\<7\> vbottom\<7\> vref vssa) inverter
    I7 (ctl\<6\> vbottom\<6\> vref vssa) inverter
    I6 (ctl\<5\> vbottom\<5\> vref vssa) inverter
    I5 (ctl\<4\> vbottom\<4\> vref vssa) inverter
    I4 (ctl\<3\> vbottom\<3\> vref vssa) inverter
    I3 (ctl\<2\> vbottom\<2\> vref vssa) inverter
    I2 (ctl\<1\> vbottom\<1\> vref vssa) inverter
    I1 (ctl\<0\> vbottom\<0\> vref vssa) inverter
    I10 (sample vin vout vdda vssa) bootstrap_sw
ends cdac_8b
subckt sarcta__C0 cn cp
    C0 (cp cn) capacitor c=1.25f
ends sarcta__C0
subckt sarct__trim_array drain n0 n1 n2 n3 n4 vss
    I5 (n4 drain) sarcta__C0
    I4 (n4 drain) sarcta__C0
    I3 (n4 drain) sarcta__C0
    I2 (n4 drain) sarcta__C0
    I1 (n4 drain) sarcta__C0
    I0 (n4 drain) sarcta__C0
    I11 (n3 drain) sarcta__C0
    I10 (n3 drain) sarcta__C0
    I9 (n3 drain) sarcta__C0
    I8 (n3 drain) sarcta__C0
    I7 (n4 drain) sarcta__C0
    I6 (n4 drain) sarcta__C0
    I17 (vss drain) sarcta__C0
    I16 (vss drain) sarcta__C0
    I15 (n0 drain) sarcta__C0
    I14 (n1 drain) sarcta__C0
    I13 (n2 drain) sarcta__C0
    I12 (n2 drain) sarcta__C0
ends sarct__trim_array
subckt trim Vss d\<4\> d\<3\> d\<2\> d\<1\> d\<0\> drain
    NM4 (net3 d\<0\> Vss Vss) nfet_01v8 w=(1u) l=300n as=265f ad=265f \
        ps=2.53u pd=2.53u m=(1)*(1)
    NM3 (net16 d\<1\> Vss Vss) nfet_01v8 w=(1u) l=300n as=265f ad=265f \
        ps=2.53u pd=2.53u m=(1)*(1)
    NM1 (net12 d\<2\> Vss Vss) nfet_01v8 w=(1u) l=300n as=265f ad=140f \
        ps=2.53u pd=1.28u m=(1)*(2)
    NM0 (net8 d\<3\> Vss Vss) nfet_01v8 w=(1u) l=300n as=202.5f ad=140f \
        ps=1.905u pd=1.28u m=(1)*(4)
    NM2 (net4 d\<4\> Vss Vss) nfet_01v8 w=(1u) l=300n as=171.25f ad=140f \
        ps=1.5925u pd=1.28u m=(1)*(8)
    I1 (drain net3 net16 net12 net8 net4 Vss) sarct__trim_array
ends trim
subckt comparator_core Clk Out_N Out_P Trima\<4\> Trima\<3\> Trima\<2\> \
        Trima\<1\> Trima\<0\> Trimb\<4\> Trimb\<3\> Trimb\<2\> Trimb\<1\> \
        Trimb\<0\> Vdd Vn Vp Vss
    PM6 (net2 Clk Vdd Vdd) pfet_01v8 w=(1u) l=300n as=265f ad=265f \
        ps=2.53u pd=2.53u m=(1)*(1)
    PM5 (net3 Clk Vdd Vdd) pfet_01v8 w=(1u) l=300n as=265f ad=265f \
        ps=2.53u pd=2.53u m=(1)*(1)
    PM4 (Out_P Clk Vdd Vdd) pfet_01v8 w=(1u) l=300n as=265f ad=265f \
        ps=2.53u pd=2.53u m=(1)*(1)
    PM3 (Out_P Out_N Vdd Vdd) pfet_01v8 w=(1u) l=300n as=265f ad=265f \
        ps=2.53u pd=2.53u m=(1)*(1)
    PM2 (Out_N Out_P Vdd Vdd) pfet_01v8 w=(1u) l=300n as=265f ad=265f \
        ps=2.53u pd=2.53u m=(1)*(1)
    PM0 (Out_N Clk Vdd Vdd) pfet_01v8 w=(1u) l=300n as=265f ad=265f \
        ps=2.53u pd=2.53u m=(1)*(1)
    NM4 (net25 Clk Vss Vss) nfet_01v8 w=(1u) l=300n as=265f ad=140f \
        ps=2.53u pd=1.28u m=(1)*(2)
    NM3 (net3 Vp net25 Vss) nfet_01v8 w=(1u) l=300n as=265f ad=265f \
        ps=2.53u pd=2.53u m=(1)*(1)
    NM2 (net2 Vn net25 Vss) nfet_01v8 w=(1u) l=300n as=265f ad=265f \
        ps=2.53u pd=2.53u m=(1)*(1)
    NM1 (Out_N Out_P net2 Vss) nfet_01v8 w=(1u) l=300n as=265f ad=265f \
        ps=2.53u pd=2.53u m=(1)*(1)
    NM0 (Out_P Out_N net3 Vss) nfet_01v8 w=(1u) l=300n as=265f ad=265f \
        ps=2.53u pd=2.53u m=(1)*(1)
    I1 (Vss Trimb\<4\> Trimb\<3\> Trimb\<2\> Trimb\<1\> Trimb\<0\> net3) \
        trim
    I0 (Vss Trima\<4\> Trima\<3\> Trima\<2\> Trima\<1\> Trima\<0\> net2) \
        trim
ends comparator_core
subckt comparator clk outn outp trima\<4\> trima\<3\> trima\<2\> \
        trima\<1\> trima\<0\> trimb\<4\> trimb\<3\> trimb\<2\> trimb\<1\> \
        trimb\<0\> vdd vn vp vss
    XCORE (clk outp outn trimb\<4\> trimb\<3\> trimb\<2\> trimb\<1\> \
        trimb\<0\> trima\<4\> trima\<3\> trima\<2\> trima\<1\> trima\<0\> \
        vdd vn vp vss) comparator_core
ends comparator
subckt sar_afe clk ctln\<7\> ctln\<6\> ctln\<5\> ctln\<4\> ctln\<3\> \
        ctln\<2\> ctln\<1\> ctln\<0\> ctlp\<7\> ctlp\<6\> ctlp\<5\> \
        ctlp\<4\> ctlp\<3\> ctlp\<2\> ctlp\<1\> ctlp\<0\> outn outp sample \
        trima\<4\> trima\<3\> trima\<2\> trima\<1\> trima\<0\> trimb\<4\> \
        trimb\<3\> trimb\<2\> trimb\<1\> trimb\<0\> vdd vinn vinp vss vdda \
        vref
    XCN (ctln\<7\> ctln\<6\> ctln\<5\> ctln\<4\> ctln\<3\> ctln\<2\> \
        ctln\<1\> ctln\<0\> vss sample vdda vinn vtopn vref vss) cdac_8b
    XCP (ctlp\<7\> ctlp\<6\> ctlp\<5\> ctlp\<4\> ctlp\<3\> ctlp\<2\> \
        ctlp\<1\> ctlp\<0\> vss sample vdda vinp vtopp vref vss) cdac_8b
    XCMP (clk outn outp trima\<4\> trima\<3\> trima\<2\> trima\<1\> \
        trima\<0\> trimb\<4\> trimb\<3\> trimb\<2\> trimb\<1\> trimb\<0\> \
        vdd vtopn vtopp vss) comparator
ends sar_afe
