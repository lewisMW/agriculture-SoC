// sky130 device-level cells for the SAR ADC - SPECTRE syntax.
//
// GENERATED by Cadence from OpenAccess (virtuoso -nograph + OCEAN createNetlist)
// on 2026-08-04. SOURCE COMMITS - pin these, do not use branch names, the
// branches move and the content changes with them:
//
//   54e94e6  origin/analog-sky130-dev  sky130_analog_lib/cdac_8b
//                                      -> cap_array_8b, inverter subckts
//   0d8dd22  origin/bootstrap-sw       bootstrap_switch_lib/bootstrap_sw
//                                      -> inv_lvt, bootstrap_sw
//   5845df0  origin/Erick_branch       sky130_analog_lib/Comparator
//                                      -> Trim, comparator_core
//
// Regenerate with AMS/netlist_sky130.il (see that file for the full procedure).
// Do NOT hand-edit the device lines - only the clearly-marked OURS wrappers are.
// NOTE: spectre syntax, so include this under simulator lang=spectre.

// ---- cap_array_8b (schematic says m=128 on the MSB; Hee 2026-08-04 LAYOUT
// ----   CDL has only 127 unit caps on bit 7 - schematic/layout disagree)
subckt cap_array_8b vbottom\<7\> vbottom\<6\> vbottom\<5\> vbottom\<4\> \
        vbottom\<3\> vbottom\<2\> vbottom\<1\> vbottom\<0\> vbottom_dum \
        vtop
    // OURS: `cu` exists only so this view accepts the same instantiation as the
    // behavioural one (cdac_8b does `cap_array_8b #(.cu(cu)) c_array`). It is
    // UNUSED - capacitance comes from the real geometry. Without it elaboration
    // fails with "*E,CUTMIP: Too many module instance parameter assignments".
    parameters cu=1f
    C8 (vtop vbottom_dum) cap_mim_m3_1 l=4u w=4u m=1
    C7 (vtop vbottom\<7\>) cap_mim_m3_1 l=4u w=4u m=128
    C6 (vtop vbottom\<6\>) cap_mim_m3_1 l=4u w=4u m=64
    C5 (vtop vbottom\<5\>) cap_mim_m3_1 l=4u w=4u m=32
    C4 (vtop vbottom\<4\>) cap_mim_m3_1 l=4u w=4u m=16
    C3 (vtop vbottom\<3\>) cap_mim_m3_1 l=4u w=4u m=8
    C2 (vtop vbottom\<2\>) cap_mim_m3_1 l=4u w=4u m=4
    C1 (vtop vbottom\<1\>) cap_mim_m3_1 l=4u w=4u m=2
    C0 (vtop vbottom\<0\>) cap_mim_m3_1 l=4u w=4u m=1
ends cap_array_8b

// ---- inverter
subckt inverter GND IN OUT VDD
    NM0 (OUT IN GND GND) nfet_01v8 w=(420n) l=150n as=111.3f ad=111.3f \
        ps=1.37u pd=1.37u m=(1)*(1)
    PM0 (OUT IN VDD VDD) pfet_01v8 w=(550n) l=150n as=145.75f ad=145.75f \
        ps=1.63u pd=1.63u m=(1)*(1)
ends inverter

// ---- inv_lvt (used by bootstrap_sw)
subckt inv_lvt in out vdd vss
    NM0 (out in vss vss) nfet_01v8_lvt w=(420n) l=150n as=111.3f ad=111.3f \
        ps=1.37u pd=1.37u m=(1)*(1)
    PM0 (out in vdd vdd) pfet_01v8_lvt w=(550n) l=350n as=145.75f \
        ad=145.75f ps=1.63u pd=1.63u m=(1)*(1)
ends inv_lvt

// ---- bootstrap_sw: generated body, wrapped in a subckt by us (it was
// ----   netlisted as the top cell, so Cadence emitted no wrapper)
subckt bootstrap_sw en in out vdd vss
    inv_lvt0 (en enb vdd vss) inv_lvt
    Ms2 (vss enb net30 vss) nfet_01v8_lvt w=(1u) l=400n as=265f ad=265f \
            ps=2.53u pd=2.53u m=(1)*(1)
    Ms1 (net30 vdd net2 vss) nfet_01v8_lvt w=(1u) l=400n as=265f ad=265f \
            ps=2.53u pd=2.53u m=(1)*(1)
    Ms (out net2 in vss) nfet_01v8_lvt w=(1u) l=500n as=265f ad=265f ps=2.53u \
            pd=2.53u m=(1)*(1)
    M1 (vbsl net2 in vss) nfet_01v8_lvt w=(1u) l=400n as=265f ad=265f ps=2.53u \
            pd=2.53u m=(1)*(1)
    M2 (vbsl enb vss vss) nfet_01v8_lvt w=(1u) l=400n as=265f ad=265f ps=2.53u \
            pd=2.53u m=(1)*(1)
    M4 (net2 enb vbsh vbsh) pfet_01v8_lvt w=(1u) l=400n as=265f ad=265f \
            ps=2.53u pd=2.53u m=(1)*(1)
    M3 (vdd net2 vbsh vbsh) pfet_01v8_lvt w=(1u) l=400n as=265f ad=265f \
            ps=2.53u pd=2.53u m=(1)*(1)
    C4 (vbsh vbsl) cap_mim_m3_1 l=5u w=5u m=1
    C2 (vbsh vbsl) cap_mim_m3_1 l=5u w=5u m=1
    C1 (vbsh vbsl) cap_mim_m3_1 l=5u w=5u m=1
    C0 (vbsh vbsl) cap_mim_m3_1 l=5u w=5u m=1
ends bootstrap_sw

// ---- OURS: alias so the cell name and ports match the behavioural
// ---- adc_analog_lib/switch_adc, letting amsd config bind it by cell name.
// ---- switch_adc(p,n,ctrl,vdd,vss) -> bootstrap_sw(en,in,out,vdd,vss):
// ----   ctrl->en, p->in (signal source), n->out (CDAC top plate).
subckt switch_adc p n ctrl vdd vss
    Xbsw (ctrl p n vdd vss) bootstrap_sw
ends switch_adc
// ---- Trim (comparator offset-trim cap array).
// ---- NOTE: ideal spectre "capacitor c=1.25f" devices, NOT sky130
// ---- MIM/MOM cells. 1.25 fF is the DESIGN INTENT; extraction of
// ---- sarct__trim_array measured ~1.10 fF/cap in-context (~12% lower,
// ---- fringe terminates on neighbouring bottom plates). This directly
// ---- sets comparator offset-trim resolution - worth reconciling.
subckt Trim Vss d\<4\> d\<3\> d\<2\> d\<1\> d\<0\> drain
    NM4 (net3 d\<0\> Vss Vss) nfet_01v8 w=(1u) l=300n as=265f ad=265f \
        ps=2.53u pd=2.53u m=(1)*(1)
    NM3 (net16 d\<1\> Vss Vss) nfet_01v8 w=(1u) l=300n as=265f ad=265f \
        ps=2.53u pd=2.53u m=(1)*(1)
    NM1 (net12 d\<2\> Vss Vss) nfet_01v8 w=(1u) l=300n as=265f ad=265f \
        ps=2.53u pd=2.53u m=(1)*(1)
    NM0 (net8 d\<3\> Vss Vss) nfet_01v8 w=(1u) l=300n as=265f ad=265f \
        ps=2.53u pd=2.53u m=(1)*(1)
    NM2 (net4 d\<4\> Vss Vss) nfet_01v8 w=(1u) l=300n as=265f ad=265f \
        ps=2.53u pd=2.53u m=(1)*(1)
    C1 (drain net16) capacitor c=1.25f m=1
    C2 (drain net12) capacitor c=1.25f m=2
    C4 (drain net4) capacitor c=1.25f m=8
    C3 (drain net8) capacitor c=1.25f m=4
    C0 (drain net3) capacitor c=1.25f m=1
ends Trim

// ---- Comparator: StrongARM-style clocked latch (clocked precharge
// ---- PMOS, Vp/Vn input pair with clocked tail, cross-coupled latch,
// ---- plus two Trim arrays injecting offset on net2/net3).
// ---- GENERATED body; the subckt wrapper line is ours because the cell
// ---- was netlisted as the top level. Port order must match the alias.
// ---- Named *_core, NOT "Comparator": spectre subckt names are
// ---- CASE-INSENSITIVE, so a wrapper named "comparator" around a
// ---- subckt named "Comparator" is a self-reference and amsspice
// ---- fails with "Recursive subcircuit call loop found".
subckt comparator_core Out_P Out_N Vdd Vss Vn Vp Clk \
        Trima\<4\> Trima\<3\> Trima\<2\> Trima\<1\> Trima\<0\> \
        Trimb\<4\> Trimb\<3\> Trimb\<2\> Trimb\<1\> Trimb\<0\>
    PM6 (net2 Clk Vdd Vdd) pfet_01v8 w=(1u) l=300n as=265f ad=265f ps=2.53u \
            pd=2.53u m=(1)*(1)
    PM5 (net3 Clk Vdd Vdd) pfet_01v8 w=(1u) l=300n as=265f ad=265f ps=2.53u \
            pd=2.53u m=(1)*(1)
    PM4 (Out_P Clk Vdd Vdd) pfet_01v8 w=(1u) l=300n as=265f ad=265f ps=2.53u \
            pd=2.53u m=(1)*(1)
    PM3 (Out_P Out_N Vdd Vdd) pfet_01v8 w=(1u) l=300n as=265f ad=265f ps=2.53u \
            pd=2.53u m=(1)*(1)
    PM2 (Out_N Out_P Vdd Vdd) pfet_01v8 w=(1u) l=300n as=265f ad=265f ps=2.53u \
            pd=2.53u m=(1)*(1)
    PM0 (Out_N Clk Vdd Vdd) pfet_01v8 w=(1u) l=300n as=265f ad=265f ps=2.53u \
            pd=2.53u m=(1)*(1)
    NM4 (net25 Clk Vss Vss) nfet_01v8 w=(1u) l=300n as=265f ad=265f ps=2.53u \
            pd=2.53u m=(1)*(1)
    NM3 (net3 Vp net25 Vss) nfet_01v8 w=(1u) l=300n as=265f ad=265f ps=2.53u \
            pd=2.53u m=(1)*(1)
    NM2 (net2 Vn net25 Vss) nfet_01v8 w=(1u) l=300n as=265f ad=265f ps=2.53u \
            pd=2.53u m=(1)*(1)
    NM1 (Out_N Out_P net2 Vss) nfet_01v8 w=(1u) l=300n as=265f ad=265f \
            ps=2.53u pd=2.53u m=(1)*(1)
    NM0 (Out_P Out_N net3 Vss) nfet_01v8 w=(1u) l=300n as=265f ad=265f \
            ps=2.53u pd=2.53u m=(1)*(1)
    I1 (Vss Trimb\<4\> Trimb\<3\> Trimb\<2\> Trimb\<1\> Trimb\<0\> net3) Trim
    I0 (Vss Trima\<4\> Trima\<3\> Trima\<2\> Trima\<1\> Trima\<0\> net2) Trim
ends comparator_core

// ---- OURS: alias so cell name AND port names match the behavioural
// ---- adc_analog_lib/comparator. Every sky130 name differs only by
// ---- case (Vp/vp, Out_P/outp, Trima/trima), and amsd config/portmap
// ---- match by name, so an explicit wrapper is clearer than casemap.
subckt comparator vp vn outp outn clk \
        trima\<4\> trima\<3\> trima\<2\> trima\<1\> trima\<0\> \
        trimb\<4\> trimb\<3\> trimb\<2\> trimb\<1\> trimb\<0\> vdd vss
    // NOTE outn/outp are CROSSED here, deliberately. The sky130 latch
    // precharges Out_P/Out_N HIGH (PM4/PM0 on Clk low) and pulls the WINNER
    // low during evaluate: Vp > Vn -> NM3 pulls net3 down -> NM0 pulls Out_P
    // LOW. The behavioural comparator uses the opposite convention
    // (outp = 1 when vp > vn), and sr_latch/sarlogic expect that. Without the
    // cross, every bit decision inverts and the SAR walks to a rail (codes
    // come out 0x00/0xff). Confirm with Erick which convention is intended -
    // this may belong in the schematic rather than here.
    Xcmp (outn outp vdd vss vn vp clk \
        trima\<4\> trima\<3\> trima\<2\> trima\<1\> trima\<0\> \
        trimb\<4\> trimb\<3\> trimb\<2\> trimb\<1\> trimb\<0\>) comparator_core
ends comparator
