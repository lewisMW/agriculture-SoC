// -----------------------------------------------------------------------------
// sar_ams_shim.vams
//
// AMS testbench glue around the chip's SAR ADC. Under SAR_AMS (Xcelium AMS
// flow) adc_apb_wrapper_rev2 instantiates this shim in place of sar_adc, with
// the same digital ports; the shim instantiates that same synthesisable
// sar_adc (agriculture_soc_main/ADC/sar_adc.v: clock divider, sarlogic, NAND
// comparator latch, sar_afe macro). The amsd file binds sar_afe to its SPICE
// netlist (amsd_sky130_afe_sch/pex.scs); without one it stays on its
// Verilog-AMS view (analog/cadence/sar_adc/sar_afe/verilogams).
//
// The shim owns what the digital chip RTL cannot express:
//   - the analog supplies for the macro: vdd/vss for the comparator, vdda
//     for the bootstrapped switches, and vref for the CDAC reference (the
//     bit drivers), with its own decoupling CDEC_REF,
//   - a differential analog input on vp/vn (stand-in sensor stimulus; the
//     wrapper's ANALOG_IN/amux path is digital-only, so it is not connected,
//     and neither are the chip's ADC_VINP/ADC_VINN wires).
// The ADC clock divider is part of sar_adc itself (CLK_DIV).
//
// Requires the AMS flow (xrun -ams) with 1.8 V connect rules.
// -----------------------------------------------------------------------------
`timescale 1ns/1ps
`include "constants.vams"
`include "disciplines.vams"

module sar_ams_shim #(
    parameter RESULT_WIDTH = 8,        // must be 8 (sar_adc is an 8-bit ADC)
    parameter CLK_DIV      = 4,        // PCLK cycles per SAR clock half-period
    parameter real VDD_V   = 1.8,      // macro digital/comparator supply
    parameter real VDDA_V  = 1.8,      // macro analog supply (sampling switches)
    parameter real VREF_V  = 1.8,      // macro CDAC reference (bit-driver inverters)
    parameter real VCM_V   = 0.9,      // input common mode
    parameter real VAMP_V  = 0.4,      // differential input amplitude
    parameter real FIN_HZ  = 5.0e3,    // input frequency
    // Supply network: RSUP models bond-wire + on-chip metal, CDEC on-chip
    // decoupling. Kept because a zero-impedance supply is unphysical, but note
    // these were NOT what fixed the device-level CDAC transient - adding them
    // changed nothing (identical codes, same stall). RSRC below was the fix.
    parameter real RSUP    = 1.0,      // supply series resistance (ohm)
    parameter real CDEC    = 10.0e-12, // decoupling capacitance (F)
    parameter real CDEC_REF = 10.0e-12, // vref decoupling (F); the chip decouples vref
                                        // heavily, so raise this to study that
    // Source impedance of the stand-in sensor driving vp/vn.
    //
    // Why this exists: it is only needed when the SAMPLING SWITCH is the
    // behavioural adc_analog_lib/switch_adc, whose ron=10 mohm is unphysical.
    // An ideal source feeding ~8.9 pF of device-level CDAC through 10 mohm is a
    // step with a ~90 fs time constant, which no timestep can resolve, and
    // Spectre stalls at minstep (~-32 mA in the vn source branch).
    //
    // With the sky130 bootstrap_sw bound instead (the sar_afe netlists) the
    // real switch supplies physical resistance and RSRC is NOT required - it
    // can be 0, which bypasses the series branch entirely and restores ideal
    // sources. Set it back to ~100 ohm if you bind the behavioural switch_adc
    // together with device-level CDAC caps.
    parameter real RSRC    = 0.0       // sensor source impedance (ohm; 0 = ideal)
)(
    input  wire                    clk,
    input  wire                    rstn,      // active-low
    input  wire                    en,        // held high through the conversion
    input  wire                    cal,       // calibration mode
    input  wire                    ANALOG_IN, // digital placeholder, unused
    output wire                    valid,
    output wire [RESULT_WIDTH-1:0] result
);

    // ── Analog supplies and stand-in differential sensor input ──────────────
    electrical vp, vn, vdd, vdda, vref, vss;
    electrical vdd_src, vdda_src, vref_src;  // ideal sources behind RSUP
    electrical vp_src, vn_src;          // ideal sines behind RSRC
    ground vss;

    analog begin
        // Supplies: ideal source -> series resistance -> decoupled rail.
        V(vdd_src)        <+ VDD_V;
        I(vdd_src, vdd)   <+ V(vdd_src, vdd)/RSUP;
        I(vdd, vss)       <+ CDEC*ddt(V(vdd, vss));
        V(vdda_src)       <+ VDDA_V;
        I(vdda_src, vdda) <+ V(vdda_src, vdda)/RSUP;
        I(vdda, vss)      <+ CDEC*ddt(V(vdda, vss));
        V(vref_src)       <+ VREF_V;
        I(vref_src, vref) <+ V(vref_src, vref)/RSUP;
        I(vref, vss)      <+ CDEC_REF*ddt(V(vref, vss));

        // Differential sensor input. RSRC is a parameter, so this selects the
        // structure once at elaboration, not during the solve.
        if (RSRC > 0.0) begin
            // Driven through a finite source impedance (needed only with the
            // behavioural 10 mohm switch_adc - see the RSRC comment above).
            V(vp_src)     <+ VCM_V + VAMP_V*sin(2.0*`M_PI*FIN_HZ*$abstime);
            V(vn_src)     <+ VCM_V - VAMP_V*sin(2.0*`M_PI*FIN_HZ*$abstime);
            I(vp_src, vp) <+ V(vp_src, vp)/RSRC;
            I(vn_src, vn) <+ V(vn_src, vn)/RSRC;
        end else begin
            // Ideal sources: fine once a real sampling switch (bootstrap_sw)
            // provides the impedance.
            V(vp_src) <+ 0.0;
            V(vn_src) <+ 0.0;
            V(vp) <+ VCM_V + VAMP_V*sin(2.0*`M_PI*FIN_HZ*$abstime);
            V(vn) <+ VCM_V - VAMP_V*sin(2.0*`M_PI*FIN_HZ*$abstime);
        end
    end

    // ── The chip's SAR ADC (same RTL as synthesis) ──────────────────────────
    sar_adc #(
        .CLK_DIV (CLK_DIV)
    ) u_sar_adc (
        .vdd    (vdd),
        .vss    (vss),
        .vdda   (vdda),
        .vref   (vref),
        .clk    (clk),
        .rstn   (rstn),
        .en     (en),
        .cal    (cal),
        .valid  (valid),
        .result (result),
        .vinp   (vp),
        .vinn   (vn)
    );

endmodule
